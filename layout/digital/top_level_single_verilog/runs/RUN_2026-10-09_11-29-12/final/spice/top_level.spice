* NGSPICE file created from top_level.ext - technology: gf180mcuD

* Black-box entry subcircuit for gf180mcu_fd_sc_mcu7t5v0__fill_2 abstract view
.subckt gf180mcu_fd_sc_mcu7t5v0__fill_2 VDD VNW VPW VSS
.ends

* Black-box entry subcircuit for gf180mcu_fd_sc_mcu7t5v0__aoi21_1 abstract view
.subckt gf180mcu_fd_sc_mcu7t5v0__aoi21_1 A1 A2 B ZN VDD VNW VPW VSS
.ends

* Black-box entry subcircuit for gf180mcu_fd_sc_mcu7t5v0__nor2_1 abstract view
.subckt gf180mcu_fd_sc_mcu7t5v0__nor2_1 A1 A2 ZN VDD VNW VPW VSS
.ends

* Black-box entry subcircuit for gf180mcu_fd_sc_mcu7t5v0__oai21_1 abstract view
.subckt gf180mcu_fd_sc_mcu7t5v0__oai21_1 A1 A2 B ZN VDD VNW VPW VSS
.ends

* Black-box entry subcircuit for gf180mcu_fd_sc_mcu7t5v0__clkinv_1 abstract view
.subckt gf180mcu_fd_sc_mcu7t5v0__clkinv_1 I ZN VDD VNW VPW VSS
.ends

* Black-box entry subcircuit for gf180mcu_fd_sc_mcu7t5v0__filltie abstract view
.subckt gf180mcu_fd_sc_mcu7t5v0__filltie VDD VSS
.ends

* Black-box entry subcircuit for gf180mcu_fd_sc_mcu7t5v0__fill_1 abstract view
.subckt gf180mcu_fd_sc_mcu7t5v0__fill_1 VDD VNW VPW VSS
.ends

* Black-box entry subcircuit for gf180mcu_fd_sc_mcu7t5v0__fillcap_8 abstract view
.subckt gf180mcu_fd_sc_mcu7t5v0__fillcap_8 VDD VNW VPW VSS
.ends

* Black-box entry subcircuit for gf180mcu_fd_sc_mcu7t5v0__fillcap_4 abstract view
.subckt gf180mcu_fd_sc_mcu7t5v0__fillcap_4 VDD VNW VPW VSS
.ends

* Black-box entry subcircuit for gf180mcu_fd_sc_mcu7t5v0__dffq_1 abstract view
.subckt gf180mcu_fd_sc_mcu7t5v0__dffq_1 D CLK Q VDD VNW VPW VSS
.ends

* Black-box entry subcircuit for gf180mcu_fd_sc_mcu7t5v0__endcap abstract view
.subckt gf180mcu_fd_sc_mcu7t5v0__endcap VDD VSS
.ends

* Black-box entry subcircuit for gf180mcu_fd_sc_mcu7t5v0__fillcap_16 abstract view
.subckt gf180mcu_fd_sc_mcu7t5v0__fillcap_16 VDD VNW VPW VSS
.ends

* Black-box entry subcircuit for gf180mcu_fd_sc_mcu7t5v0__xnor2_1 abstract view
.subckt gf180mcu_fd_sc_mcu7t5v0__xnor2_1 A1 A2 ZN VDD VNW VPW VSS
.ends

* Black-box entry subcircuit for gf180mcu_fd_sc_mcu7t5v0__nand2_1 abstract view
.subckt gf180mcu_fd_sc_mcu7t5v0__nand2_1 A1 A2 ZN VDD VNW VPW VSS
.ends

* Black-box entry subcircuit for gf180mcu_fd_sc_mcu7t5v0__dlyc_1 abstract view
.subckt gf180mcu_fd_sc_mcu7t5v0__dlyc_1 I Z VDD VNW VPW VSS
.ends

* Black-box entry subcircuit for gf180mcu_fd_sc_mcu7t5v0__fillcap_32 abstract view
.subckt gf180mcu_fd_sc_mcu7t5v0__fillcap_32 VDD VNW VPW VSS
.ends

* Black-box entry subcircuit for gf180mcu_fd_sc_mcu7t5v0__mux2_2 abstract view
.subckt gf180mcu_fd_sc_mcu7t5v0__mux2_2 I0 I1 S Z VDD VNW VPW VSS
.ends

* Black-box entry subcircuit for gf180mcu_fd_sc_mcu7t5v0__aoi22_1 abstract view
.subckt gf180mcu_fd_sc_mcu7t5v0__aoi22_1 A1 A2 B1 B2 ZN VDD VNW VPW VSS
.ends

* Black-box entry subcircuit for gf180mcu_fd_sc_mcu7t5v0__aoi211_1 abstract view
.subckt gf180mcu_fd_sc_mcu7t5v0__aoi211_1 A1 A2 B C ZN VDD VNW VPW VSS
.ends

* Black-box entry subcircuit for gf180mcu_fd_sc_mcu7t5v0__xor2_1 abstract view
.subckt gf180mcu_fd_sc_mcu7t5v0__xor2_1 A1 A2 Z VDD VNW VPW VSS
.ends

* Black-box entry subcircuit for gf180mcu_fd_sc_mcu7t5v0__clkbuf_16 abstract view
.subckt gf180mcu_fd_sc_mcu7t5v0__clkbuf_16 I Z VDD VNW VPW VSS
.ends

* Black-box entry subcircuit for gf180mcu_fd_sc_mcu7t5v0__buf_4 abstract view
.subckt gf180mcu_fd_sc_mcu7t5v0__buf_4 I Z VDD VNW VPW VSS
.ends

* Black-box entry subcircuit for gf180mcu_fd_sc_mcu7t5v0__or3_1 abstract view
.subckt gf180mcu_fd_sc_mcu7t5v0__or3_1 A1 A2 A3 Z VDD VNW VPW VSS
.ends

* Black-box entry subcircuit for gf180mcu_fd_sc_mcu7t5v0__and4_1 abstract view
.subckt gf180mcu_fd_sc_mcu7t5v0__and4_1 A1 A2 A3 A4 Z VDD VNW VPW VSS
.ends

* Black-box entry subcircuit for gf180mcu_fd_sc_mcu7t5v0__nor3_1 abstract view
.subckt gf180mcu_fd_sc_mcu7t5v0__nor3_1 A1 A2 A3 ZN VDD VNW VPW VSS
.ends

* Black-box entry subcircuit for gf180mcu_fd_sc_mcu7t5v0__clkbuf_8 abstract view
.subckt gf180mcu_fd_sc_mcu7t5v0__clkbuf_8 I Z VDD VNW VPW VSS
.ends

* Black-box entry subcircuit for gf180mcu_fd_sc_mcu7t5v0__dlyb_1 abstract view
.subckt gf180mcu_fd_sc_mcu7t5v0__dlyb_1 I Z VDD VNW VPW VSS
.ends

* Black-box entry subcircuit for gf180mcu_fd_sc_mcu7t5v0__aoi221_1 abstract view
.subckt gf180mcu_fd_sc_mcu7t5v0__aoi221_1 A1 A2 B1 B2 C ZN VDD VNW VPW VSS
.ends

* Black-box entry subcircuit for gf180mcu_fd_sc_mcu7t5v0__nand3_1 abstract view
.subckt gf180mcu_fd_sc_mcu7t5v0__nand3_1 A1 A2 A3 ZN VDD VNW VPW VSS
.ends

* Black-box entry subcircuit for gf180mcu_fd_sc_mcu7t5v0__xor3_1 abstract view
.subckt gf180mcu_fd_sc_mcu7t5v0__xor3_1 A1 A2 A3 Z VDD VNW VPW VSS
.ends

* Black-box entry subcircuit for gf180mcu_fd_sc_mcu7t5v0__nor4_1 abstract view
.subckt gf180mcu_fd_sc_mcu7t5v0__nor4_1 A1 A2 A3 A4 ZN VDD VNW VPW VSS
.ends

* Black-box entry subcircuit for gf180mcu_fd_sc_mcu7t5v0__and2_1 abstract view
.subckt gf180mcu_fd_sc_mcu7t5v0__and2_1 A1 A2 Z VDD VNW VPW VSS
.ends

* Black-box entry subcircuit for gf180mcu_fd_sc_mcu7t5v0__oai22_1 abstract view
.subckt gf180mcu_fd_sc_mcu7t5v0__oai22_1 A1 A2 B1 B2 ZN VDD VNW VPW VSS
.ends

* Black-box entry subcircuit for gf180mcu_fd_sc_mcu7t5v0__oai211_1 abstract view
.subckt gf180mcu_fd_sc_mcu7t5v0__oai211_1 A1 A2 B C ZN VDD VNW VPW VSS
.ends

* Black-box entry subcircuit for gf180mcu_fd_sc_mcu7t5v0__or2_1 abstract view
.subckt gf180mcu_fd_sc_mcu7t5v0__or2_1 A1 A2 Z VDD VNW VPW VSS
.ends

* Black-box entry subcircuit for gf180mcu_fd_sc_mcu7t5v0__aoi222_1 abstract view
.subckt gf180mcu_fd_sc_mcu7t5v0__aoi222_1 A1 A2 B1 B2 C1 C2 ZN VDD VNW VPW VSS
.ends

* Black-box entry subcircuit for gf180mcu_fd_sc_mcu7t5v0__tieh abstract view
.subckt gf180mcu_fd_sc_mcu7t5v0__tieh Z VDD VNW VPW VSS
.ends

* Black-box entry subcircuit for gf180mcu_fd_sc_mcu7t5v0__oai221_1 abstract view
.subckt gf180mcu_fd_sc_mcu7t5v0__oai221_1 A1 A2 B1 B2 C ZN VDD VNW VPW VSS
.ends

* Black-box entry subcircuit for gf180mcu_fd_sc_mcu7t5v0__fillcap_64 abstract view
.subckt gf180mcu_fd_sc_mcu7t5v0__fillcap_64 VDD VNW VPW VSS
.ends

* Black-box entry subcircuit for gf180mcu_fd_sc_mcu7t5v0__or4_1 abstract view
.subckt gf180mcu_fd_sc_mcu7t5v0__or4_1 A1 A2 A3 A4 Z VDD VNW VPW VSS
.ends

* Black-box entry subcircuit for gf180mcu_fd_sc_mcu7t5v0__tiel abstract view
.subckt gf180mcu_fd_sc_mcu7t5v0__tiel ZN VDD VNW VPW VSS
.ends

* Black-box entry subcircuit for gf180mcu_fd_sc_mcu7t5v0__oai222_1 abstract view
.subckt gf180mcu_fd_sc_mcu7t5v0__oai222_1 A1 A2 B1 B2 C1 C2 ZN VDD VNW VPW VSS
.ends

* Black-box entry subcircuit for gf180mcu_fd_sc_mcu7t5v0__inv_3 abstract view
.subckt gf180mcu_fd_sc_mcu7t5v0__inv_3 I ZN VDD VNW VPW VSS
.ends

* Black-box entry subcircuit for gf180mcu_fd_sc_mcu7t5v0__oai31_1 abstract view
.subckt gf180mcu_fd_sc_mcu7t5v0__oai31_1 A1 A2 A3 B ZN VDD VNW VPW VSS
.ends

* Black-box entry subcircuit for gf180mcu_fd_sc_mcu7t5v0__clkbuf_2 abstract view
.subckt gf180mcu_fd_sc_mcu7t5v0__clkbuf_2 I Z VDD VNW VPW VSS
.ends

* Black-box entry subcircuit for gf180mcu_fd_sc_mcu7t5v0__inv_2 abstract view
.subckt gf180mcu_fd_sc_mcu7t5v0__inv_2 I ZN VDD VNW VPW VSS
.ends

* Black-box entry subcircuit for gf180mcu_fd_sc_mcu7t5v0__and3_1 abstract view
.subckt gf180mcu_fd_sc_mcu7t5v0__and3_1 A1 A2 A3 Z VDD VNW VPW VSS
.ends

* Black-box entry subcircuit for gf180mcu_fd_sc_mcu7t5v0__oai21_2 abstract view
.subckt gf180mcu_fd_sc_mcu7t5v0__oai21_2 A1 A2 B ZN VDD VNW VPW VSS
.ends

* Black-box entry subcircuit for gf180mcu_fd_sc_mcu7t5v0__nand4_1 abstract view
.subckt gf180mcu_fd_sc_mcu7t5v0__nand4_1 A1 A2 A3 A4 ZN VDD VNW VPW VSS
.ends

* Black-box entry subcircuit for gf180mcu_fd_sc_mcu7t5v0__clkinv_4 abstract view
.subckt gf180mcu_fd_sc_mcu7t5v0__clkinv_4 I ZN VDD VNW VPW VSS
.ends

* Black-box entry subcircuit for gf180mcu_fd_sc_mcu7t5v0__clkinv_8 abstract view
.subckt gf180mcu_fd_sc_mcu7t5v0__clkinv_8 I ZN VDD VNW VPW VSS
.ends

* Black-box entry subcircuit for gf180mcu_fd_sc_mcu7t5v0__buf_2 abstract view
.subckt gf180mcu_fd_sc_mcu7t5v0__buf_2 I Z VDD VNW VPW VSS
.ends

* Black-box entry subcircuit for gf180mcu_fd_sc_mcu7t5v0__inv_4 abstract view
.subckt gf180mcu_fd_sc_mcu7t5v0__inv_4 I ZN VDD VNW VPW VSS
.ends

* Black-box entry subcircuit for gf180mcu_fd_sc_mcu7t5v0__clkinv_3 abstract view
.subckt gf180mcu_fd_sc_mcu7t5v0__clkinv_3 I ZN VDD VNW VPW VSS
.ends

* Black-box entry subcircuit for gf180mcu_fd_sc_mcu7t5v0__clkbuf_4 abstract view
.subckt gf180mcu_fd_sc_mcu7t5v0__clkbuf_4 I Z VDD VNW VPW VSS
.ends

* Black-box entry subcircuit for gf180mcu_fd_sc_mcu7t5v0__aoi211_2 abstract view
.subckt gf180mcu_fd_sc_mcu7t5v0__aoi211_2 A1 A2 B C ZN VDD VNW VPW VSS
.ends

* Black-box entry subcircuit for gf180mcu_fd_sc_mcu7t5v0__buf_1 abstract view
.subckt gf180mcu_fd_sc_mcu7t5v0__buf_1 I Z VDD VNW VPW VSS
.ends

* Black-box entry subcircuit for gf180mcu_fd_sc_mcu7t5v0__buf_3 abstract view
.subckt gf180mcu_fd_sc_mcu7t5v0__buf_3 I Z VDD VNW VPW VSS
.ends

* Black-box entry subcircuit for gf180mcu_fd_sc_mcu7t5v0__clkbuf_3 abstract view
.subckt gf180mcu_fd_sc_mcu7t5v0__clkbuf_3 I Z VDD VNW VPW VSS
.ends

* Black-box entry subcircuit for gf180mcu_fd_sc_mcu7t5v0__buf_12 abstract view
.subckt gf180mcu_fd_sc_mcu7t5v0__buf_12 I Z VDD VNW VPW VSS
.ends

* Black-box entry subcircuit for gf180mcu_fd_sc_mcu7t5v0__and2_2 abstract view
.subckt gf180mcu_fd_sc_mcu7t5v0__and2_2 A1 A2 Z VDD VNW VPW VSS
.ends

* Black-box entry subcircuit for gf180mcu_fd_sc_mcu7t5v0__oai32_1 abstract view
.subckt gf180mcu_fd_sc_mcu7t5v0__oai32_1 A1 A2 A3 B1 B2 ZN VDD VNW VPW VSS
.ends

* Black-box entry subcircuit for gf180mcu_fd_sc_mcu7t5v0__buf_16 abstract view
.subckt gf180mcu_fd_sc_mcu7t5v0__buf_16 I Z VDD VNW VPW VSS
.ends

* Black-box entry subcircuit for gf180mcu_fd_sc_mcu7t5v0__mux4_1 abstract view
.subckt gf180mcu_fd_sc_mcu7t5v0__mux4_1 I0 I1 I2 I3 S0 S1 Z VDD VNW VPW VSS
.ends

* Black-box entry subcircuit for gf180mcu_fd_sc_mcu7t5v0__clkbuf_1 abstract view
.subckt gf180mcu_fd_sc_mcu7t5v0__clkbuf_1 I Z VDD VNW VPW VSS
.ends

.subckt top_level BPF_OUT IN_BPF IN_SCHMITT JUNCTION OTA_IN_M PAD_A[0] PAD_A[1] PAD_CS[0]
+ PAD_CS[1] PAD_IE[0] PAD_IE[1] PAD_OE[0] PAD_OE[1] PAD_PDRV0[0] PAD_PDRV0[1] PAD_PDRV1[0]
+ PAD_PDRV1[1] PAD_PD[0] PAD_PD[1] PAD_PU[0] PAD_PU[1] PAD_SL[0] PAD_SL[1] PAD_Y[0]
+ PAD_Y[1] RX_IN_N RX_IN_P VDD VSS bypass_pin_control[0] bypass_pin_control[1] bypass_pin_control[2]
+ ext_clk_in ext_clk_in_pd_control ext_clk_in_pu_control ext_rst_n_in i2c_scl_in i2c_scl_in_pd_control
+ i2c_scl_in_pu_control i2c_sda_in i2c_sda_out_cs_control i2c_sda_out_pd_control i2c_sda_out_pdrv_control[0]
+ i2c_sda_out_pdrv_control[1] i2c_sda_out_pin_ctrl i2c_sda_out_pin_ctrl_n i2c_sda_out_pu_control
+ i2c_sda_out_sl_control nrst_in_pd_control nrst_in_pu_control pga_gain_control[0]
+ pga_gain_control[1] pga_gain_control[2] signal_input trig_out_cs_control trig_out_ie_control
+ trig_out_oe_control trig_out_pd_control trig_out_pdrv_control[0] trig_out_pdrv_control[1]
+ trig_out_pu_control trig_out_sl_control trigger_signal_out
XFILLER_100_127 VDD VDD VSS VSS gf180mcu_fd_sc_mcu7t5v0__fill_2
XFILLER_27_417 VDD VDD VSS VSS gf180mcu_fd_sc_mcu7t5v0__fill_2
X_3155_ _3155_/A1 _3155_/A2 _3155_/B _3974_/D VDD VDD VSS VSS gf180mcu_fd_sc_mcu7t5v0__aoi21_1
X_2106_ _3840_/Q _2930_/A2 _2940_/A3 VDD VDD VSS VSS gf180mcu_fd_sc_mcu7t5v0__nor2_1
X_3086_ _3848_/Q _3087_/A2 wire81/I _3087_/B VDD VDD VSS VSS gf180mcu_fd_sc_mcu7t5v0__oai21_1
X_2037_ _3882_/Q _2464_/A2 VDD VDD VSS VSS gf180mcu_fd_sc_mcu7t5v0__clkinv_1
XTAP_TAPCELL_ROW_80_735 VDD VSS gf180mcu_fd_sc_mcu7t5v0__filltie
XFILLER_22_122 VDD VDD VSS VSS gf180mcu_fd_sc_mcu7t5v0__fill_1
XFILLER_22_111 VDD VDD VSS VSS gf180mcu_fd_sc_mcu7t5v0__fill_2
XFILLER_52_18 VDD VDD VSS VSS gf180mcu_fd_sc_mcu7t5v0__fillcap_8
XFILLER_10_317 VDD VDD VSS VSS gf180mcu_fd_sc_mcu7t5v0__fillcap_4
X_3988_ _3988_/D clkload2/I _3988_/Q VDD VDD VSS VSS gf180mcu_fd_sc_mcu7t5v0__dffq_1
XPHY_EDGE_ROW_99_Left_221 VDD VSS gf180mcu_fd_sc_mcu7t5v0__endcap
XFILLER_22_177 VDD VDD VSS VSS gf180mcu_fd_sc_mcu7t5v0__fillcap_16
X_2939_ _3720_/A2 _2954_/A1 _3037_/C2 VDD VDD VSS VSS gf180mcu_fd_sc_mcu7t5v0__nor2_1
XFILLER_117_22 VDD VDD VSS VSS gf180mcu_fd_sc_mcu7t5v0__fill_1
XFILLER_89_100 VDD VDD VSS VSS gf180mcu_fd_sc_mcu7t5v0__fill_2
XFILLER_117_77 VDD VDD VSS VSS gf180mcu_fd_sc_mcu7t5v0__fillcap_8
XFILLER_92_309 VDD VDD VSS VSS gf180mcu_fd_sc_mcu7t5v0__fillcap_4
XTAP_TAPCELL_ROW_28_423 VDD VSS gf180mcu_fd_sc_mcu7t5v0__filltie
XFILLER_107_282 VDD VDD VSS VSS gf180mcu_fd_sc_mcu7t5v0__fill_1
XFILLER_68_317 VDD VDD VSS VSS gf180mcu_fd_sc_mcu7t5v0__fill_1
XFILLER_95_103 VDD VDD VSS VSS gf180mcu_fd_sc_mcu7t5v0__fillcap_16
XFILLER_110_425 VDD VDD VSS VSS gf180mcu_fd_sc_mcu7t5v0__fill_1
XFILLER_3_78 VDD VDD VSS VSS gf180mcu_fd_sc_mcu7t5v0__fill_1
XTAP_TAPCELL_ROW_94_816 VDD VSS gf180mcu_fd_sc_mcu7t5v0__filltie
XFILLER_36_247 VDD VDD VSS VSS gf180mcu_fd_sc_mcu7t5v0__fillcap_8
X_3911_ _3911_/D _4034_/CLK _3911_/Q VDD VDD VSS VSS gf180mcu_fd_sc_mcu7t5v0__dffq_1
XTAP_TAPCELL_ROW_34_459 VDD VSS gf180mcu_fd_sc_mcu7t5v0__filltie
X_3842_ _3842_/D clkload3/I _3842_/Q VDD VDD VSS VSS gf180mcu_fd_sc_mcu7t5v0__dffq_1
X_3773_ _3773_/D _4058_/CLK _3773_/Q VDD VDD VSS VSS gf180mcu_fd_sc_mcu7t5v0__dffq_1
X_2724_ _2760_/C _2723_/Z _3889_/D VDD VDD VSS VSS gf180mcu_fd_sc_mcu7t5v0__nor2_1
X_2655_ _4025_/Q _3903_/Q _2656_/B VDD VDD VSS VSS gf180mcu_fd_sc_mcu7t5v0__xnor2_1
X_2586_ _2599_/A1 _2586_/A2 _2589_/A2 VDD VDD VSS VSS gf180mcu_fd_sc_mcu7t5v0__nor2_1
X_3207_ _3207_/A1 _3275_/A2 _3223_/A2 VDD VDD VSS VSS gf180mcu_fd_sc_mcu7t5v0__nand2_1
X_3138_ _3138_/A1 _3138_/A2 _3138_/B _3966_/D VDD VDD VSS VSS gf180mcu_fd_sc_mcu7t5v0__aoi21_1
XTAP_TAPCELL_ROW_25_404 VDD VSS gf180mcu_fd_sc_mcu7t5v0__filltie
X_3069_ wire90/Z _3082_/A2 wire81/Z _3070_/B VDD VDD VSS VSS gf180mcu_fd_sc_mcu7t5v0__oai21_1
XTAP_TAPCELL_ROW_120_975 VDD VSS gf180mcu_fd_sc_mcu7t5v0__filltie
XFILLER_6_107 VDD VDD VSS VSS gf180mcu_fd_sc_mcu7t5v0__fillcap_8
XFILLER_2_313 VDD VDD VSS VSS gf180mcu_fd_sc_mcu7t5v0__fill_2
XFILLER_88_25 VDD VDD VSS VSS gf180mcu_fd_sc_mcu7t5v0__fill_1
Xhold170 _4013_/Q _1932_/I VDD VDD VSS VSS gf180mcu_fd_sc_mcu7t5v0__dlyc_1
Xhold181 _4149_/Q hold181/Z VDD VDD VSS VSS gf180mcu_fd_sc_mcu7t5v0__dlyc_1
Xhold192 _4042_/Q hold192/Z VDD VDD VSS VSS gf180mcu_fd_sc_mcu7t5v0__dlyc_1
XFILLER_104_274 VDD VDD VSS VSS gf180mcu_fd_sc_mcu7t5v0__fillcap_32
XFILLER_77_114 VDD VDD VSS VSS gf180mcu_fd_sc_mcu7t5v0__fill_2
XFILLER_18_247 VDD VDD VSS VSS gf180mcu_fd_sc_mcu7t5v0__fillcap_16
XTAP_TAPCELL_ROW_111_920 VDD VSS gf180mcu_fd_sc_mcu7t5v0__filltie
X_2440_ _3858_/Q _2451_/A2 _2442_/A2 VDD VDD VSS VSS gf180mcu_fd_sc_mcu7t5v0__nand2_1
X_2371_ _3829_/Q _3830_/Q _2372_/S _3830_/D VDD VDD VSS VSS gf180mcu_fd_sc_mcu7t5v0__mux2_2
XFILLER_68_103 VDD VDD VSS VSS gf180mcu_fd_sc_mcu7t5v0__fill_2
X_4110_ _4110_/D clkload5/I _4110_/Q VDD VDD VSS VSS gf180mcu_fd_sc_mcu7t5v0__dffq_1
X_4041_ _4041_/D _4058_/CLK _4041_/Q VDD VDD VSS VSS gf180mcu_fd_sc_mcu7t5v0__dffq_1
XFILLER_20_423 VDD VDD VSS VSS gf180mcu_fd_sc_mcu7t5v0__fill_2
X_3825_ _3825_/D clkload8/I _3825_/Q VDD VDD VSS VSS gf180mcu_fd_sc_mcu7t5v0__dffq_1
X_3756_ _3756_/A1 _3757_/S _3756_/B _4154_/D VDD VDD VSS VSS gf180mcu_fd_sc_mcu7t5v0__aoi21_1
XFILLER_118_366 VDD VDD VSS VSS gf180mcu_fd_sc_mcu7t5v0__fill_1
X_2707_ _2760_/C _2706_/Z _3886_/D VDD VDD VSS VSS gf180mcu_fd_sc_mcu7t5v0__nor2_1
X_3687_ wire91/Z _3678_/Z _3688_/B VDD VDD VSS VSS gf180mcu_fd_sc_mcu7t5v0__nand2_1
X_2638_ _4017_/Q _2776_/A2 _2763_/A2 _4016_/Q _2639_/B2 VDD VDD VSS VSS gf180mcu_fd_sc_mcu7t5v0__aoi22_1
X_2569_ _3998_/Q _2856_/A2 _2569_/B _2619_/A1 VDD VDD VSS VSS gf180mcu_fd_sc_mcu7t5v0__aoi21_1
XFILLER_114_34 VDD VDD VSS VSS gf180mcu_fd_sc_mcu7t5v0__fill_1
XFILLER_101_244 VDD VDD VSS VSS gf180mcu_fd_sc_mcu7t5v0__fill_1
XFILLER_114_45 VDD VDD VSS VSS gf180mcu_fd_sc_mcu7t5v0__fillcap_4
XFILLER_74_16 VDD VDD VSS VSS gf180mcu_fd_sc_mcu7t5v0__fillcap_4
XPHY_EDGE_ROW_27_Left_149 VDD VSS gf180mcu_fd_sc_mcu7t5v0__endcap
XFILLER_23_42 VDD VDD VSS VSS gf180mcu_fd_sc_mcu7t5v0__fillcap_8
XFILLER_109_300 VDD VDD VSS VSS gf180mcu_fd_sc_mcu7t5v0__fillcap_4
XFILLER_7_416 VDD VDD VSS VSS gf180mcu_fd_sc_mcu7t5v0__fillcap_4
XFILLER_109_333 VDD VDD VSS VSS gf180mcu_fd_sc_mcu7t5v0__fill_2
XPHY_EDGE_ROW_36_Left_158 VDD VSS gf180mcu_fd_sc_mcu7t5v0__endcap
XFILLER_2_165 VDD VDD VSS VSS gf180mcu_fd_sc_mcu7t5v0__fillcap_8
XPHY_EDGE_ROW_45_Left_167 VDD VSS gf180mcu_fd_sc_mcu7t5v0__endcap
XFILLER_65_139 VDD VDD VSS VSS gf180mcu_fd_sc_mcu7t5v0__fill_1
XFILLER_64_71 VDD VDD VSS VSS gf180mcu_fd_sc_mcu7t5v0__fill_2
XFILLER_64_82 VDD VDD VSS VSS gf180mcu_fd_sc_mcu7t5v0__fillcap_4
XFILLER_73_194 VDD VDD VSS VSS gf180mcu_fd_sc_mcu7t5v0__fill_1
X_1940_ _4005_/Q _3221_/A1 VDD VDD VSS VSS gf180mcu_fd_sc_mcu7t5v0__clkinv_1
XFILLER_9_55 VDD VDD VSS VSS gf180mcu_fd_sc_mcu7t5v0__fill_1
XPHY_EDGE_ROW_54_Left_176 VDD VSS gf180mcu_fd_sc_mcu7t5v0__endcap
X_3610_ _4149_/Q _3748_/A1 _3726_/A1 _4143_/Q _3612_/A1 VDD VDD VSS VSS gf180mcu_fd_sc_mcu7t5v0__aoi22_1
XPHY_EDGE_ROW_104_Right_104 VDD VSS gf180mcu_fd_sc_mcu7t5v0__endcap
X_3541_ _1891_/I _3541_/A2 _3541_/B _3552_/C _4099_/D VDD VDD VSS VSS gf180mcu_fd_sc_mcu7t5v0__aoi211_1
X_3472_ _4082_/Q _3479_/A2 _3549_/B _3472_/B2 _3473_/A2 VDD VDD VSS VSS gf180mcu_fd_sc_mcu7t5v0__aoi22_1
X_2423_ _3874_/Q _2454_/A3 _2424_/A2 VDD VDD VSS VSS gf180mcu_fd_sc_mcu7t5v0__nand2_1
XFILLER_43_2 VDD VDD VSS VSS gf180mcu_fd_sc_mcu7t5v0__fill_2
XFILLER_88_209 VDD VDD VSS VSS gf180mcu_fd_sc_mcu7t5v0__fillcap_4
X_2354_ _2354_/A1 _2360_/A2 _2356_/A2 VDD VDD VSS VSS gf180mcu_fd_sc_mcu7t5v0__nor2_1
XFILLER_96_253 VDD VDD VSS VSS gf180mcu_fd_sc_mcu7t5v0__fill_1
XFILLER_96_242 VDD VDD VSS VSS gf180mcu_fd_sc_mcu7t5v0__fill_2
XFILLER_96_264 VDD VDD VSS VSS gf180mcu_fd_sc_mcu7t5v0__fillcap_4
X_2285_ _3856_/Q _3826_/Q _2285_/Z VDD VDD VSS VSS gf180mcu_fd_sc_mcu7t5v0__xor2_1
XPHY_EDGE_ROW_63_Left_185 VDD VSS gf180mcu_fd_sc_mcu7t5v0__endcap
XTAP_TAPCELL_ROW_67_657 VDD VSS gf180mcu_fd_sc_mcu7t5v0__filltie
X_4024_ _4024_/D _4166_/CLK _4024_/Q VDD VDD VSS VSS gf180mcu_fd_sc_mcu7t5v0__dffq_1
XFILLER_64_161 VDD VDD VSS VSS gf180mcu_fd_sc_mcu7t5v0__fill_1
XFILLER_60_18 VDD VDD VSS VSS gf180mcu_fd_sc_mcu7t5v0__fillcap_8
XPHY_EDGE_ROW_72_Left_194 VDD VSS gf180mcu_fd_sc_mcu7t5v0__endcap
XFILLER_20_275 VDD VDD VSS VSS gf180mcu_fd_sc_mcu7t5v0__fillcap_4
X_3808_ _3808_/D clkload7/I _3808_/Q VDD VDD VSS VSS gf180mcu_fd_sc_mcu7t5v0__dffq_1
XFILLER_4_419 VDD VDD VSS VSS gf180mcu_fd_sc_mcu7t5v0__fillcap_4
X_3739_ _3739_/A1 _3739_/A2 _4144_/D VDD VDD VSS VSS gf180mcu_fd_sc_mcu7t5v0__nor2_1
XFILLER_106_314 VDD VDD VSS VSS gf180mcu_fd_sc_mcu7t5v0__fill_1
Xclkbuf_0__1468_ _3454_/ZN clkbuf_0__1468_/Z VDD VDD VSS VSS gf180mcu_fd_sc_mcu7t5v0__clkbuf_16
XFILLER_69_49 VDD VDD VSS VSS gf180mcu_fd_sc_mcu7t5v0__fill_2
XFILLER_87_220 VDD VDD VSS VSS gf180mcu_fd_sc_mcu7t5v0__fillcap_4
XFILLER_85_26 VDD VDD VSS VSS gf180mcu_fd_sc_mcu7t5v0__fillcap_4
XTAP_TAPCELL_ROW_58_602 VDD VSS gf180mcu_fd_sc_mcu7t5v0__filltie
XFILLER_18_31 VDD VDD VSS VSS gf180mcu_fd_sc_mcu7t5v0__fillcap_4
XFILLER_62_109 VDD VDD VSS VSS gf180mcu_fd_sc_mcu7t5v0__fill_1
XFILLER_112_317 VDD VDD VSS VSS gf180mcu_fd_sc_mcu7t5v0__fillcap_16
XFILLER_78_253 VDD VDD VSS VSS gf180mcu_fd_sc_mcu7t5v0__fill_2
XFILLER_93_212 VDD VDD VSS VSS gf180mcu_fd_sc_mcu7t5v0__fillcap_4
X_2070_ _3887_/Q _2714_/A2 VDD VDD VSS VSS gf180mcu_fd_sc_mcu7t5v0__clkinv_1
XTAP_TAPCELL_ROW_6_290 VDD VSS gf180mcu_fd_sc_mcu7t5v0__filltie
XFILLER_78_297 VDD VDD VSS VSS gf180mcu_fd_sc_mcu7t5v0__fill_2
XTAP_TAPCELL_ROW_64_638 VDD VSS gf180mcu_fd_sc_mcu7t5v0__filltie
Xload_slew85 _4157_/Q _2345_/C VDD VDD VSS VSS gf180mcu_fd_sc_mcu7t5v0__buf_4
XTAP_TAPCELL_ROW_72_682 VDD VSS gf180mcu_fd_sc_mcu7t5v0__filltie
X_2972_ _3994_/Q _3190_/A1 _3258_/A1 _4026_/Q _2973_/A3 VDD VDD VSS VSS gf180mcu_fd_sc_mcu7t5v0__aoi22_1
X_1923_ _4022_/Q _3257_/A1 VDD VDD VSS VSS gf180mcu_fd_sc_mcu7t5v0__clkinv_1
X_3524_ _3536_/A2 _3526_/A2 _4095_/Q _3528_/A2 VDD VDD VSS VSS gf180mcu_fd_sc_mcu7t5v0__aoi21_1
X_3455_ _4104_/Q _3549_/A1 _3455_/A3 _3455_/Z VDD VDD VSS VSS gf180mcu_fd_sc_mcu7t5v0__or3_1
XFILLER_103_306 VDD VDD VSS VSS gf180mcu_fd_sc_mcu7t5v0__fillcap_8
X_2406_ wire94/I wire51/Z _2404_/B _3807_/Q _2407_/I VDD VDD VSS VSS gf180mcu_fd_sc_mcu7t5v0__aoi22_1
X_3386_ _3386_/A1 _3386_/A2 _3386_/A3 _3386_/A4 _3386_/Z VDD VDD VSS VSS gf180mcu_fd_sc_mcu7t5v0__and4_1
X_2337_ _2356_/B _2361_/A2 VDD VDD VSS VSS gf180mcu_fd_sc_mcu7t5v0__clkinv_1
X_2268_ _3866_/Q _2354_/A1 _2269_/A3 VDD VDD VSS VSS gf180mcu_fd_sc_mcu7t5v0__nand2_1
X_4007_ _4007_/D clkload1/I _4007_/Q VDD VDD VSS VSS gf180mcu_fd_sc_mcu7t5v0__dffq_1
X_2199_ _2199_/A1 _2199_/A2 _3786_/D VDD VDD VSS VSS gf180mcu_fd_sc_mcu7t5v0__nor2_1
XTAP_TAPCELL_ROW_107_897 VDD VSS gf180mcu_fd_sc_mcu7t5v0__filltie
XPHY_EDGE_ROW_80_Left_202 VDD VSS gf180mcu_fd_sc_mcu7t5v0__endcap
XFILLER_20_54 VDD VDD VSS VSS gf180mcu_fd_sc_mcu7t5v0__fillcap_4
XFILLER_106_177 VDD VDD VSS VSS gf180mcu_fd_sc_mcu7t5v0__fillcap_32
XFILLER_121_169 VDD VDD VSS VSS gf180mcu_fd_sc_mcu7t5v0__fill_1
XFILLER_29_30 VDD VDD VSS VSS gf180mcu_fd_sc_mcu7t5v0__fill_2
XFILLER_75_212 VDD VDD VSS VSS gf180mcu_fd_sc_mcu7t5v0__fillcap_4
XTAP_TAPCELL_ROW_78_719 VDD VSS gf180mcu_fd_sc_mcu7t5v0__filltie
XTAP_TAPCELL_ROW_3_271 VDD VSS gf180mcu_fd_sc_mcu7t5v0__filltie
XPHY_EDGE_ROW_119_Left_241 VDD VSS gf180mcu_fd_sc_mcu7t5v0__endcap
XFILLER_43_142 VDD VDD VSS VSS gf180mcu_fd_sc_mcu7t5v0__fillcap_4
XFILLER_43_186 VDD VDD VSS VSS gf180mcu_fd_sc_mcu7t5v0__fill_2
XTAP_TAPCELL_ROW_61_619 VDD VSS gf180mcu_fd_sc_mcu7t5v0__filltie
XFILLER_61_72 VDD VDD VSS VSS gf180mcu_fd_sc_mcu7t5v0__fillcap_4
XFILLER_112_158 VDD VDD VSS VSS gf180mcu_fd_sc_mcu7t5v0__fillcap_16
XFILLER_3_282 VDD VDD VSS VSS gf180mcu_fd_sc_mcu7t5v0__fill_2
X_3240_ _3240_/A1 _3240_/A2 _3240_/B _4014_/D VDD VDD VSS VSS gf180mcu_fd_sc_mcu7t5v0__aoi21_1
XFILLER_20_4 VDD VDD VSS VSS gf180mcu_fd_sc_mcu7t5v0__fill_1
X_3171_ _3290_/A1 _3172_/A2 wire81/I _3172_/B VDD VDD VSS VSS gf180mcu_fd_sc_mcu7t5v0__oai21_1
XFILLER_120_191 VDD VDD VSS VSS gf180mcu_fd_sc_mcu7t5v0__fillcap_16
X_2122_ hold192/Z _2155_/A2 _2124_/A1 VDD VDD VSS VSS gf180mcu_fd_sc_mcu7t5v0__nor2_1
XFILLER_66_267 VDD VDD VSS VSS gf180mcu_fd_sc_mcu7t5v0__fill_1
X_2053_ _3907_/Q _2847_/A2 VDD VDD VSS VSS gf180mcu_fd_sc_mcu7t5v0__clkinv_1
XFILLER_19_194 VDD VDD VSS VSS gf180mcu_fd_sc_mcu7t5v0__fillcap_16
XTAP_TAPCELL_ROW_104_878 VDD VSS gf180mcu_fd_sc_mcu7t5v0__filltie
X_2955_ _3597_/A2 _2958_/A2 _3012_/A2 VDD VDD VSS VSS gf180mcu_fd_sc_mcu7t5v0__nor2_1
X_2886_ _2929_/A1 _2890_/B _2886_/A3 _3911_/D VDD VDD VSS VSS gf180mcu_fd_sc_mcu7t5v0__nor3_1
X_1906_ _4063_/Q _3398_/A3 VDD VDD VSS VSS gf180mcu_fd_sc_mcu7t5v0__clkinv_1
XTAP_TAPCELL_ROW_9_308 VDD VSS gf180mcu_fd_sc_mcu7t5v0__filltie
X_3507_ _4091_/Q _4090_/Q _4089_/Q _3496_/Z _3508_/I VDD VDD VSS VSS gf180mcu_fd_sc_mcu7t5v0__and4_1
X_3438_ _3436_/Z _3438_/A2 _4078_/D VDD VDD VSS VSS gf180mcu_fd_sc_mcu7t5v0__nor2_1
XFILLER_103_147 VDD VDD VSS VSS gf180mcu_fd_sc_mcu7t5v0__fillcap_8
X_3369_ _4138_/Q _4078_/Q _3370_/C VDD VDD VSS VSS gf180mcu_fd_sc_mcu7t5v0__xor2_1
Xclkbuf_leaf_14_ext_clk_in clkbuf_leaf_1_ext_clk_in/I clkload4/I VDD VDD VSS VSS gf180mcu_fd_sc_mcu7t5v0__clkbuf_8
XFILLER_106_79 VDD VDD VSS VSS gf180mcu_fd_sc_mcu7t5v0__fillcap_8
XFILLER_72_226 VDD VDD VSS VSS gf180mcu_fd_sc_mcu7t5v0__fill_2
XFILLER_25_142 VDD VDD VSS VSS gf180mcu_fd_sc_mcu7t5v0__fill_2
XTAP_TAPCELL_ROW_0_252 VDD VSS gf180mcu_fd_sc_mcu7t5v0__filltie
XFILLER_31_20 VDD VDD VSS VSS gf180mcu_fd_sc_mcu7t5v0__fill_2
XFILLER_31_64 VDD VDD VSS VSS gf180mcu_fd_sc_mcu7t5v0__fillcap_4
XFILLER_31_97 VDD VDD VSS VSS gf180mcu_fd_sc_mcu7t5v0__fill_1
Xoutput20 _4195_/Z bypass_pin_control[0] VDD VDD VSS VSS gf180mcu_fd_sc_mcu7t5v0__dlyb_1
Xoutput7 output7/I PAD_A[1] VDD VDD VSS VSS gf180mcu_fd_sc_mcu7t5v0__dlyb_1
XFILLER_0_274 VDD VDD VSS VSS gf180mcu_fd_sc_mcu7t5v0__fillcap_32
XTAP_TAPCELL_ROW_118_959 VDD VSS gf180mcu_fd_sc_mcu7t5v0__filltie
XFILLER_71_270 VDD VDD VSS VSS gf180mcu_fd_sc_mcu7t5v0__fill_2
XTAP_TAPCELL_ROW_101_859 VDD VSS gf180mcu_fd_sc_mcu7t5v0__filltie
X_2740_ _3950_/Q _3892_/Q _2748_/A2 VDD VDD VSS VSS gf180mcu_fd_sc_mcu7t5v0__nand2_1
X_2671_ _2683_/C _3911_/Q _2873_/A2 _4032_/Q _2671_/C _2693_/A2 VDD VDD VSS VSS gf180mcu_fd_sc_mcu7t5v0__aoi221_1
XFILLER_98_156 VDD VDD VSS VSS gf180mcu_fd_sc_mcu7t5v0__fillcap_8
X_3223_ _3223_/A1 _3223_/A2 _3223_/B _4006_/D VDD VDD VSS VSS gf180mcu_fd_sc_mcu7t5v0__aoi21_1
XTAP_TAPCELL_ROW_97_836 VDD VSS gf180mcu_fd_sc_mcu7t5v0__filltie
XTAP_TAPCELL_ROW_109_904 VDD VSS gf180mcu_fd_sc_mcu7t5v0__filltie
X_3154_ _3290_/A1 _3155_/A2 wire81/Z _3155_/B VDD VDD VSS VSS gf180mcu_fd_sc_mcu7t5v0__oai21_1
X_3085_ _3085_/A1 _3087_/A2 _3085_/B _3941_/D VDD VDD VSS VSS gf180mcu_fd_sc_mcu7t5v0__aoi21_1
X_2105_ _2105_/A1 _3592_/A1 _3720_/A1 VDD VDD VSS VSS gf180mcu_fd_sc_mcu7t5v0__nand2_1
XFILLER_94_373 VDD VDD VSS VSS gf180mcu_fd_sc_mcu7t5v0__fillcap_4
X_2036_ _4161_/Q _2376_/A1 VDD VDD VSS VSS gf180mcu_fd_sc_mcu7t5v0__clkinv_1
X_3987_ _3987_/D clkload2/I _3987_/Q VDD VDD VSS VSS gf180mcu_fd_sc_mcu7t5v0__dffq_1
X_2938_ _3842_/Q _2940_/A2 _2938_/A3 _2954_/A1 VDD VDD VSS VSS gf180mcu_fd_sc_mcu7t5v0__nand3_1
X_2869_ _2897_/A1 _2868_/Z _2884_/A1 VDD VDD VSS VSS gf180mcu_fd_sc_mcu7t5v0__nand2_1
XFILLER_117_56 VDD VDD VSS VSS gf180mcu_fd_sc_mcu7t5v0__fill_2
XFILLER_26_31 VDD VDD VSS VSS gf180mcu_fd_sc_mcu7t5v0__fillcap_4
XFILLER_42_63 VDD VDD VSS VSS gf180mcu_fd_sc_mcu7t5v0__fill_1
XTAP_TAPCELL_ROW_94_817 VDD VSS gf180mcu_fd_sc_mcu7t5v0__filltie
XFILLER_91_321 VDD VDD VSS VSS gf180mcu_fd_sc_mcu7t5v0__fillcap_4
X_3910_ _3910_/D _4170_/CLK _3910_/Q VDD VDD VSS VSS gf180mcu_fd_sc_mcu7t5v0__dffq_1
X_3841_ _3841_/D _4142_/CLK _3841_/Q VDD VDD VSS VSS gf180mcu_fd_sc_mcu7t5v0__dffq_1
X_3772_ _3772_/D _4058_/CLK _3772_/Q VDD VDD VSS VSS gf180mcu_fd_sc_mcu7t5v0__dffq_1
X_2723_ _2719_/I _2721_/Z _2723_/Z VDD VDD VSS VSS gf180mcu_fd_sc_mcu7t5v0__xor2_1
XFILLER_8_182 VDD VDD VSS VSS gf180mcu_fd_sc_mcu7t5v0__fillcap_4
X_2654_ _3272_/A1 _3907_/Q _2654_/B _2690_/B VDD VDD VSS VSS gf180mcu_fd_sc_mcu7t5v0__oai21_1
X_2585_ _3987_/Q _2784_/A2 _2756_/A2 _3983_/Q _2589_/A1 VDD VDD VSS VSS gf180mcu_fd_sc_mcu7t5v0__aoi22_1
XFILLER_105_209 VDD VDD VSS VSS gf180mcu_fd_sc_mcu7t5v0__fill_1
XFILLER_86_104 VDD VDD VSS VSS gf180mcu_fd_sc_mcu7t5v0__fill_1
X_3206_ _3206_/A1 _3206_/A2 _3206_/B _3998_/D VDD VDD VSS VSS gf180mcu_fd_sc_mcu7t5v0__aoi21_1
X_3137_ _3854_/Q _3138_/A2 wire81/Z _3138_/B VDD VDD VSS VSS gf180mcu_fd_sc_mcu7t5v0__oai21_1
XFILLER_27_226 VDD VDD VSS VSS gf180mcu_fd_sc_mcu7t5v0__fill_1
XPHY_EDGE_ROW_118_Right_118 VDD VSS gf180mcu_fd_sc_mcu7t5v0__endcap
XTAP_TAPCELL_ROW_25_405 VDD VSS gf180mcu_fd_sc_mcu7t5v0__filltie
XFILLER_82_387 VDD VDD VSS VSS gf180mcu_fd_sc_mcu7t5v0__fill_1
X_3068_ _3068_/A1 _3080_/A2 _3068_/B _3933_/D VDD VDD VSS VSS gf180mcu_fd_sc_mcu7t5v0__aoi21_1
X_2019_ _3860_/Q _2487_/B2 VDD VDD VSS VSS gf180mcu_fd_sc_mcu7t5v0__clkinv_1
XFILLER_6_119 VDD VDD VSS VSS gf180mcu_fd_sc_mcu7t5v0__fill_2
Xclkbuf_leaf_4_ext_clk_in clkload0/I _4170_/CLK VDD VDD VSS VSS gf180mcu_fd_sc_mcu7t5v0__clkbuf_8
Xhold171 _3816_/Q hold171/Z VDD VDD VSS VSS gf180mcu_fd_sc_mcu7t5v0__dlyc_1
Xhold160 _4114_/Q hold160/Z VDD VDD VSS VSS gf180mcu_fd_sc_mcu7t5v0__dlyc_1
Xhold182 _4118_/Q hold182/Z VDD VDD VSS VSS gf180mcu_fd_sc_mcu7t5v0__dlyc_1
Xhold193 hold193/I _3761_/D VDD VDD VSS VSS gf180mcu_fd_sc_mcu7t5v0__dlyc_1
XFILLER_92_107 VDD VDD VSS VSS gf180mcu_fd_sc_mcu7t5v0__fill_1
XFILLER_37_52 VDD VDD VSS VSS gf180mcu_fd_sc_mcu7t5v0__fill_1
XFILLER_58_395 VDD VDD VSS VSS gf180mcu_fd_sc_mcu7t5v0__fill_2
XTAP_TAPCELL_ROW_111_921 VDD VSS gf180mcu_fd_sc_mcu7t5v0__filltie
XFILLER_53_84 VDD VDD VSS VSS gf180mcu_fd_sc_mcu7t5v0__fill_2
X_2370_ _3828_/Q _3829_/Q _2372_/S _3829_/D VDD VDD VSS VSS gf180mcu_fd_sc_mcu7t5v0__mux2_2
XFILLER_68_115 VDD VDD VSS VSS gf180mcu_fd_sc_mcu7t5v0__fillcap_4
XFILLER_78_92 VDD VDD VSS VSS gf180mcu_fd_sc_mcu7t5v0__fill_1
XFILLER_96_424 VDD VDD VSS VSS gf180mcu_fd_sc_mcu7t5v0__fill_2
X_4040_ _4040_/D _4164_/CLK _4040_/Q VDD VDD VSS VSS gf180mcu_fd_sc_mcu7t5v0__dffq_1
XFILLER_76_181 VDD VDD VSS VSS gf180mcu_fd_sc_mcu7t5v0__fill_1
XFILLER_17_270 VDD VDD VSS VSS gf180mcu_fd_sc_mcu7t5v0__fillcap_8
XFILLER_32_240 VDD VDD VSS VSS gf180mcu_fd_sc_mcu7t5v0__fillcap_4
X_3824_ _3824_/D _4021_/CLK _3824_/Q VDD VDD VSS VSS gf180mcu_fd_sc_mcu7t5v0__dffq_1
XTAP_TAPCELL_ROW_30_430 VDD VSS gf180mcu_fd_sc_mcu7t5v0__filltie
XFILLER_32_295 VDD VDD VSS VSS gf180mcu_fd_sc_mcu7t5v0__fillcap_8
X_3755_ _4199_/I _3757_/S _3756_/B VDD VDD VSS VSS gf180mcu_fd_sc_mcu7t5v0__nor2_1
X_2706_ _3092_/A1 _2706_/A2 _2710_/A1 _2706_/Z VDD VDD VSS VSS gf180mcu_fd_sc_mcu7t5v0__xor3_1
X_3686_ _3686_/A1 _3686_/A2 _4126_/D VDD VDD VSS VSS gf180mcu_fd_sc_mcu7t5v0__nor2_1
XPHY_EDGE_ROW_12_Right_12 VDD VSS gf180mcu_fd_sc_mcu7t5v0__endcap
X_2637_ _2637_/A1 _2637_/A2 _2637_/B _2639_/B1 VDD VDD VSS VSS gf180mcu_fd_sc_mcu7t5v0__oai21_1
X_2568_ _2602_/A2 _2568_/A2 _2568_/B _2568_/C _2569_/B VDD VDD VSS VSS gf180mcu_fd_sc_mcu7t5v0__aoi211_1
XFILLER_99_262 VDD VDD VSS VSS gf180mcu_fd_sc_mcu7t5v0__fillcap_4
X_2499_ _2455_/Z _2499_/A2 _2463_/Z _2555_/A3 VDD VDD VSS VSS gf180mcu_fd_sc_mcu7t5v0__nand3_1
XFILLER_59_137 VDD VDD VSS VSS gf180mcu_fd_sc_mcu7t5v0__fill_2
XFILLER_99_284 VDD VDD VSS VSS gf180mcu_fd_sc_mcu7t5v0__fill_1
XFILLER_101_212 VDD VDD VSS VSS gf180mcu_fd_sc_mcu7t5v0__fillcap_8
XFILLER_74_107 VDD VDD VSS VSS gf180mcu_fd_sc_mcu7t5v0__fillcap_8
XFILLER_74_129 VDD VDD VSS VSS gf180mcu_fd_sc_mcu7t5v0__fillcap_4
XFILLER_101_267 VDD VDD VSS VSS gf180mcu_fd_sc_mcu7t5v0__fill_2
X_4169_ input1/Z _4169_/CLK _4169_/Q VDD VDD VSS VSS gf180mcu_fd_sc_mcu7t5v0__dffq_1
XPHY_EDGE_ROW_21_Right_21 VDD VSS gf180mcu_fd_sc_mcu7t5v0__endcap
XFILLER_15_207 VDD VDD VSS VSS gf180mcu_fd_sc_mcu7t5v0__fill_2
XFILLER_70_302 VDD VDD VSS VSS gf180mcu_fd_sc_mcu7t5v0__fillcap_4
XPHY_EDGE_ROW_30_Right_30 VDD VSS gf180mcu_fd_sc_mcu7t5v0__endcap
XFILLER_3_2 VDD VDD VSS VSS gf180mcu_fd_sc_mcu7t5v0__fill_2
XPHY_EDGE_ROW_100_Left_222 VDD VSS gf180mcu_fd_sc_mcu7t5v0__endcap
XFILLER_0_36 VDD VDD VSS VSS gf180mcu_fd_sc_mcu7t5v0__fill_2
XFILLER_46_387 VDD VDD VSS VSS gf180mcu_fd_sc_mcu7t5v0__fill_2
XFILLER_9_23 VDD VDD VSS VSS gf180mcu_fd_sc_mcu7t5v0__fillcap_16
XFILLER_80_93 VDD VDD VSS VSS gf180mcu_fd_sc_mcu7t5v0__fill_2
X_3540_ _4098_/Q _3540_/A2 _4099_/Q _3541_/B VDD VDD VSS VSS gf180mcu_fd_sc_mcu7t5v0__aoi21_1
X_3471_ _4082_/Q _3471_/A2 _3472_/B2 VDD VDD VSS VSS gf180mcu_fd_sc_mcu7t5v0__xnor2_1
X_2422_ _3876_/Q _3875_/Q _3878_/Q _3877_/Q _2454_/A3 VDD VDD VSS VSS gf180mcu_fd_sc_mcu7t5v0__nor4_1
XFILLER_89_91 VDD VDD VSS VSS gf180mcu_fd_sc_mcu7t5v0__fill_1
X_2353_ _3822_/Q _3821_/Q _2360_/A3 VDD VDD VSS VSS gf180mcu_fd_sc_mcu7t5v0__nand2_1
XFILLER_36_2 VDD VDD VSS VSS gf180mcu_fd_sc_mcu7t5v0__fillcap_16
X_2284_ _3859_/Q _3829_/Q _2284_/Z VDD VDD VSS VSS gf180mcu_fd_sc_mcu7t5v0__xor2_1
XFILLER_56_107 VDD VDD VSS VSS gf180mcu_fd_sc_mcu7t5v0__fill_2
X_4023_ _4023_/D _4166_/CLK _4023_/Q VDD VDD VSS VSS gf180mcu_fd_sc_mcu7t5v0__dffq_1
X_3807_ _3807_/D _4021_/CLK _3807_/Q VDD VDD VSS VSS gf180mcu_fd_sc_mcu7t5v0__dffq_1
XFILLER_118_120 VDD VDD VSS VSS gf180mcu_fd_sc_mcu7t5v0__fill_2
X_1999_ _3946_/Q _3096_/A1 VDD VDD VSS VSS gf180mcu_fd_sc_mcu7t5v0__clkinv_1
X_3738_ _3751_/I1 _3746_/A2 _3746_/B _3739_/A2 VDD VDD VSS VSS gf180mcu_fd_sc_mcu7t5v0__oai21_1
X_3669_ _4121_/Q _3669_/A2 _3669_/B1 _3669_/B2 _3670_/A2 VDD VDD VSS VSS gf180mcu_fd_sc_mcu7t5v0__aoi22_1
Xclkbuf_0__1536_ _3546_/ZN clkbuf_0__1536_/Z VDD VDD VSS VSS gf180mcu_fd_sc_mcu7t5v0__clkbuf_16
XFILLER_109_57 VDD VDD VSS VSS gf180mcu_fd_sc_mcu7t5v0__fillcap_4
XTAP_TAPCELL_ROW_58_603 VDD VSS gf180mcu_fd_sc_mcu7t5v0__filltie
XFILLER_28_321 VDD VDD VSS VSS gf180mcu_fd_sc_mcu7t5v0__fill_2
XFILLER_50_85 VDD VDD VSS VSS gf180mcu_fd_sc_mcu7t5v0__fillcap_8
XFILLER_78_210 VDD VDD VSS VSS gf180mcu_fd_sc_mcu7t5v0__fill_2
XFILLER_59_72 VDD VDD VSS VSS gf180mcu_fd_sc_mcu7t5v0__fillcap_16
XFILLER_38_118 VDD VDD VSS VSS gf180mcu_fd_sc_mcu7t5v0__fill_1
XFILLER_78_265 VDD VDD VSS VSS gf180mcu_fd_sc_mcu7t5v0__fillcap_4
XFILLER_78_287 VDD VDD VSS VSS gf180mcu_fd_sc_mcu7t5v0__fill_1
XFILLER_120_384 VDD VDD VSS VSS gf180mcu_fd_sc_mcu7t5v0__fill_1
XTAP_TAPCELL_ROW_6_291 VDD VSS gf180mcu_fd_sc_mcu7t5v0__filltie
XFILLER_81_419 VDD VDD VSS VSS gf180mcu_fd_sc_mcu7t5v0__fill_1
XFILLER_34_302 VDD VDD VSS VSS gf180mcu_fd_sc_mcu7t5v0__fillcap_4
XFILLER_46_173 VDD VDD VSS VSS gf180mcu_fd_sc_mcu7t5v0__fill_2
XTAP_TAPCELL_ROW_64_639 VDD VSS gf180mcu_fd_sc_mcu7t5v0__filltie
XFILLER_34_379 VDD VDD VSS VSS gf180mcu_fd_sc_mcu7t5v0__fillcap_4
XTAP_TAPCELL_ROW_72_683 VDD VSS gf180mcu_fd_sc_mcu7t5v0__filltie
X_2971_ _4034_/Q _3275_/A1 _3122_/A1 _3962_/Q _2973_/A2 VDD VDD VSS VSS gf180mcu_fd_sc_mcu7t5v0__aoi22_1
X_1922_ _4023_/Q _3260_/A1 VDD VDD VSS VSS gf180mcu_fd_sc_mcu7t5v0__clkinv_1
X_3523_ _3523_/A1 _3523_/A2 _3523_/B _3552_/C _4094_/D VDD VDD VSS VSS gf180mcu_fd_sc_mcu7t5v0__aoi211_1
X_3454_ _3454_/A1 _3454_/A2 _3454_/ZN VDD VDD VSS VSS gf180mcu_fd_sc_mcu7t5v0__nand2_1
X_2405_ _2405_/I _3846_/D VDD VDD VSS VSS gf180mcu_fd_sc_mcu7t5v0__clkinv_1
XFILLER_103_318 VDD VDD VSS VSS gf180mcu_fd_sc_mcu7t5v0__fill_2
X_3385_ _4129_/Q _3385_/A2 _3385_/B1 _4127_/Q _3385_/C _3386_/A4 VDD VDD VSS VSS gf180mcu_fd_sc_mcu7t5v0__aoi221_1
XFILLER_111_362 VDD VDD VSS VSS gf180mcu_fd_sc_mcu7t5v0__fill_1
X_2336_ _2336_/A1 _2336_/A2 _2356_/B VDD VDD VSS VSS gf180mcu_fd_sc_mcu7t5v0__nand2_1
X_2267_ _2357_/A1 _3821_/Q _3865_/Q _2269_/A2 VDD VDD VSS VSS gf180mcu_fd_sc_mcu7t5v0__nand3_1
XFILLER_37_151 VDD VDD VSS VSS gf180mcu_fd_sc_mcu7t5v0__fill_1
X_4006_ _4006_/D _4166_/CLK _4006_/Q VDD VDD VSS VSS gf180mcu_fd_sc_mcu7t5v0__dffq_1
X_2198_ _3786_/Q _2111_/Z _3746_/B _2199_/A2 VDD VDD VSS VSS gf180mcu_fd_sc_mcu7t5v0__oai21_1
XFILLER_33_390 VDD VDD VSS VSS gf180mcu_fd_sc_mcu7t5v0__fillcap_16
XFILLER_20_33 VDD VDD VSS VSS gf180mcu_fd_sc_mcu7t5v0__fill_2
XFILLER_121_104 VDD VDD VSS VSS gf180mcu_fd_sc_mcu7t5v0__fillcap_32
XFILLER_121_148 VDD VDD VSS VSS gf180mcu_fd_sc_mcu7t5v0__fill_1
XFILLER_96_37 VDD VDD VSS VSS gf180mcu_fd_sc_mcu7t5v0__fillcap_8
XFILLER_102_362 VDD VDD VSS VSS gf180mcu_fd_sc_mcu7t5v0__fillcap_4
XFILLER_75_268 VDD VDD VSS VSS gf180mcu_fd_sc_mcu7t5v0__fillcap_8
XFILLER_90_205 VDD VDD VSS VSS gf180mcu_fd_sc_mcu7t5v0__fillcap_4
XFILLER_28_184 VDD VDD VSS VSS gf180mcu_fd_sc_mcu7t5v0__fillcap_8
XFILLER_28_173 VDD VDD VSS VSS gf180mcu_fd_sc_mcu7t5v0__fill_2
XTAP_TAPCELL_ROW_3_272 VDD VSS gf180mcu_fd_sc_mcu7t5v0__filltie
XFILLER_43_121 VDD VDD VSS VSS gf180mcu_fd_sc_mcu7t5v0__fillcap_16
XFILLER_83_290 VDD VDD VSS VSS gf180mcu_fd_sc_mcu7t5v0__fillcap_8
XFILLER_43_154 VDD VDD VSS VSS gf180mcu_fd_sc_mcu7t5v0__fill_2
XFILLER_31_349 VDD VDD VSS VSS gf180mcu_fd_sc_mcu7t5v0__fill_1
XFILLER_112_126 VDD VDD VSS VSS gf180mcu_fd_sc_mcu7t5v0__fillcap_32
X_3170_ _3170_/A1 _3170_/A2 _3170_/B _3981_/D VDD VDD VSS VSS gf180mcu_fd_sc_mcu7t5v0__aoi21_1
XFILLER_66_235 VDD VDD VSS VSS gf180mcu_fd_sc_mcu7t5v0__fill_1
X_2121_ _2121_/A1 _2121_/A2 _3760_/D VDD VDD VSS VSS gf180mcu_fd_sc_mcu7t5v0__nor2_1
X_2052_ _3908_/Q _2856_/A2 VDD VDD VSS VSS gf180mcu_fd_sc_mcu7t5v0__clkinv_1
XFILLER_81_216 VDD VDD VSS VSS gf180mcu_fd_sc_mcu7t5v0__fill_2
XFILLER_81_227 VDD VDD VSS VSS gf180mcu_fd_sc_mcu7t5v0__fill_1
XTAP_TAPCELL_ROW_17_352 VDD VSS gf180mcu_fd_sc_mcu7t5v0__filltie
XTAP_TAPCELL_ROW_104_879 VDD VSS gf180mcu_fd_sc_mcu7t5v0__filltie
X_2954_ _2954_/A1 _2947_/Z _3013_/B1 VDD VDD VSS VSS gf180mcu_fd_sc_mcu7t5v0__nor2_1
X_2885_ _2885_/A1 _2885_/A2 _2885_/B _2886_/A3 VDD VDD VSS VSS gf180mcu_fd_sc_mcu7t5v0__aoi21_1
X_1905_ _4066_/Q _3382_/A2 VDD VDD VSS VSS gf180mcu_fd_sc_mcu7t5v0__clkinv_1
XPHY_EDGE_ROW_6_Right_6 VDD VSS gf180mcu_fd_sc_mcu7t5v0__endcap
XTAP_TAPCELL_ROW_9_309 VDD VSS gf180mcu_fd_sc_mcu7t5v0__filltie
X_3506_ _3506_/A1 _3506_/A2 _3506_/B _3552_/C _4090_/D VDD VDD VSS VSS gf180mcu_fd_sc_mcu7t5v0__aoi211_1
XFILLER_1_209 VDD VDD VSS VSS gf180mcu_fd_sc_mcu7t5v0__fill_1
XFILLER_103_115 VDD VDD VSS VSS gf180mcu_fd_sc_mcu7t5v0__fillcap_4
X_3437_ _4078_/Q _3433_/Z _3439_/B _3438_/A2 VDD VDD VSS VSS gf180mcu_fd_sc_mcu7t5v0__oai21_1
XFILLER_103_159 VDD VDD VSS VSS gf180mcu_fd_sc_mcu7t5v0__fill_1
X_3368_ _3683_/A1 _4065_/Q _3373_/B VDD VDD VSS VSS gf180mcu_fd_sc_mcu7t5v0__nand2_1
XFILLER_106_69 VDD VDD VSS VSS gf180mcu_fd_sc_mcu7t5v0__fillcap_4
X_2319_ _4158_/Q _2319_/A2 _2332_/A2 VDD VDD VSS VSS gf180mcu_fd_sc_mcu7t5v0__nand2_1
XFILLER_57_257 VDD VDD VSS VSS gf180mcu_fd_sc_mcu7t5v0__fill_1
X_3299_ _4040_/Q _3295_/Z _3299_/Z VDD VDD VSS VSS gf180mcu_fd_sc_mcu7t5v0__and2_1
XFILLER_25_132 VDD VDD VSS VSS gf180mcu_fd_sc_mcu7t5v0__fillcap_8
XTAP_TAPCELL_ROW_0_253 VDD VSS gf180mcu_fd_sc_mcu7t5v0__filltie
XFILLER_15_55 VDD VDD VSS VSS gf180mcu_fd_sc_mcu7t5v0__fill_1
XFILLER_13_349 VDD VDD VSS VSS gf180mcu_fd_sc_mcu7t5v0__fill_1
XTAP_TAPCELL_ROW_23_388 VDD VSS gf180mcu_fd_sc_mcu7t5v0__filltie
XFILLER_31_32 VDD VDD VSS VSS gf180mcu_fd_sc_mcu7t5v0__fill_2
Xoutput21 _4196_/Z bypass_pin_control[1] VDD VDD VSS VSS gf180mcu_fd_sc_mcu7t5v0__dlyb_1
Xoutput8 _3932_/Q PAD_CS[0] VDD VDD VSS VSS gf180mcu_fd_sc_mcu7t5v0__dlyb_1
Xoutput10 _3070_/A1 PAD_IE[0] VDD VDD VSS VSS gf180mcu_fd_sc_mcu7t5v0__dlyb_1
Xclkbuf_regs_0_signal_clock signal_input clkbuf_regs_0_signal_clock/Z VDD VDD VSS
+ VSS gf180mcu_fd_sc_mcu7t5v0__clkbuf_16
XFILLER_36_419 VDD VDD VSS VSS gf180mcu_fd_sc_mcu7t5v0__fillcap_4
XFILLER_71_282 VDD VDD VSS VSS gf180mcu_fd_sc_mcu7t5v0__fillcap_32
XFILLER_72_72 VDD VDD VSS VSS gf180mcu_fd_sc_mcu7t5v0__fillcap_8
XPHY_EDGE_ROW_59_Right_59 VDD VSS gf180mcu_fd_sc_mcu7t5v0__endcap
Xclkbuf_0_ext_clk_in ext_clk_in clkbuf_0_ext_clk_in/Z VDD VDD VSS VSS gf180mcu_fd_sc_mcu7t5v0__clkbuf_16
X_2670_ _3283_/A1 _3912_/Q _3911_/Q _2683_/C _2671_/C VDD VDD VSS VSS gf180mcu_fd_sc_mcu7t5v0__oai22_1
X_3222_ _3290_/A1 _3223_/A2 wire81/Z _3223_/B VDD VDD VSS VSS gf180mcu_fd_sc_mcu7t5v0__oai21_1
XFILLER_98_168 VDD VDD VSS VSS gf180mcu_fd_sc_mcu7t5v0__fillcap_4
XFILLER_100_107 VDD VDD VSS VSS gf180mcu_fd_sc_mcu7t5v0__fillcap_16
XTAP_TAPCELL_ROW_109_905 VDD VSS gf180mcu_fd_sc_mcu7t5v0__filltie
X_3153_ _3153_/A1 _3155_/A2 _3153_/B _3973_/D VDD VDD VSS VSS gf180mcu_fd_sc_mcu7t5v0__aoi21_1
XPHY_EDGE_ROW_68_Right_68 VDD VSS gf180mcu_fd_sc_mcu7t5v0__endcap
XTAP_TAPCELL_ROW_97_837 VDD VSS gf180mcu_fd_sc_mcu7t5v0__filltie
XFILLER_100_129 VDD VDD VSS VSS gf180mcu_fd_sc_mcu7t5v0__fill_1
X_2104_ _2105_/A1 _3592_/A1 _2104_/Z VDD VDD VSS VSS gf180mcu_fd_sc_mcu7t5v0__and2_1
XFILLER_27_419 VDD VDD VSS VSS gf180mcu_fd_sc_mcu7t5v0__fill_1
XFILLER_39_279 VDD VDD VSS VSS gf180mcu_fd_sc_mcu7t5v0__fill_1
X_3084_ wire94/I _3087_/A2 wire81/Z _3085_/B VDD VDD VSS VSS gf180mcu_fd_sc_mcu7t5v0__oai21_1
X_2035_ _4163_/Q _2377_/A1 VDD VDD VSS VSS gf180mcu_fd_sc_mcu7t5v0__clkinv_1
XFILLER_62_260 VDD VDD VSS VSS gf180mcu_fd_sc_mcu7t5v0__fillcap_8
XFILLER_22_113 VDD VDD VSS VSS gf180mcu_fd_sc_mcu7t5v0__fill_1
XFILLER_50_422 VDD VDD VSS VSS gf180mcu_fd_sc_mcu7t5v0__fillcap_4
X_3986_ _3986_/D clkload1/I _3986_/Q VDD VDD VSS VSS gf180mcu_fd_sc_mcu7t5v0__dffq_1
XPHY_EDGE_ROW_77_Right_77 VDD VSS gf180mcu_fd_sc_mcu7t5v0__endcap
XFILLER_22_168 VDD VDD VSS VSS gf180mcu_fd_sc_mcu7t5v0__fillcap_4
X_2937_ _3838_/Q _2947_/A2 _3720_/A2 VDD VDD VSS VSS gf180mcu_fd_sc_mcu7t5v0__nand2_1
X_2868_ _3967_/Q _3909_/Q _2868_/Z VDD VDD VSS VSS gf180mcu_fd_sc_mcu7t5v0__xor2_1
X_2799_ _2762_/I _2779_/C _2776_/B _2805_/A3 _2799_/Z VDD VDD VSS VSS gf180mcu_fd_sc_mcu7t5v0__and4_1
XFILLER_89_102 VDD VDD VSS VSS gf180mcu_fd_sc_mcu7t5v0__fill_1
XFILLER_104_424 VDD VDD VSS VSS gf180mcu_fd_sc_mcu7t5v0__fill_2
XPHY_EDGE_ROW_86_Right_86 VDD VSS gf180mcu_fd_sc_mcu7t5v0__endcap
XFILLER_18_419 VDD VDD VSS VSS gf180mcu_fd_sc_mcu7t5v0__fillcap_4
XFILLER_41_422 VDD VDD VSS VSS gf180mcu_fd_sc_mcu7t5v0__fillcap_4
XFILLER_53_282 VDD VDD VSS VSS gf180mcu_fd_sc_mcu7t5v0__fillcap_4
XPHY_EDGE_ROW_95_Right_95 VDD VSS gf180mcu_fd_sc_mcu7t5v0__endcap
XFILLER_95_127 VDD VDD VSS VSS gf180mcu_fd_sc_mcu7t5v0__fillcap_4
XFILLER_67_72 VDD VDD VSS VSS gf180mcu_fd_sc_mcu7t5v0__fillcap_32
XTAP_TAPCELL_ROW_94_818 VDD VSS gf180mcu_fd_sc_mcu7t5v0__filltie
XFILLER_51_208 VDD VDD VSS VSS gf180mcu_fd_sc_mcu7t5v0__fill_2
X_3840_ _3840_/D clkload3/I _3840_/Q VDD VDD VSS VSS gf180mcu_fd_sc_mcu7t5v0__dffq_1
X_3771_ _3771_/D _4052_/CLK _3771_/Q VDD VDD VSS VSS gf180mcu_fd_sc_mcu7t5v0__dffq_1
X_2722_ _2722_/A1 _2721_/Z _2727_/B VDD VDD VSS VSS gf180mcu_fd_sc_mcu7t5v0__nor2_1
XFILLER_66_2 VDD VDD VSS VSS gf180mcu_fd_sc_mcu7t5v0__fillcap_4
X_2653_ _3272_/A1 _3907_/Q _2653_/B _2654_/B VDD VDD VSS VSS gf180mcu_fd_sc_mcu7t5v0__aoi21_1
X_2584_ _3172_/A1 _3892_/Q _2586_/A2 VDD VDD VSS VSS gf180mcu_fd_sc_mcu7t5v0__nor2_1
XFILLER_99_422 VDD VDD VSS VSS gf180mcu_fd_sc_mcu7t5v0__fillcap_4
X_3205_ _3290_/A1 _3206_/A2 wire81/Z _3206_/B VDD VDD VSS VSS gf180mcu_fd_sc_mcu7t5v0__oai21_1
X_3136_ _3136_/A1 _3136_/A2 _3136_/B _3965_/D VDD VDD VSS VSS gf180mcu_fd_sc_mcu7t5v0__aoi21_1
X_3067_ wire90/Z _3080_/A2 wire81/Z _3068_/B VDD VDD VSS VSS gf180mcu_fd_sc_mcu7t5v0__oai21_1
X_2018_ _3814_/Q _2548_/A1 VDD VDD VSS VSS gf180mcu_fd_sc_mcu7t5v0__clkinv_1
XFILLER_23_422 VDD VDD VSS VSS gf180mcu_fd_sc_mcu7t5v0__fillcap_4
XFILLER_35_260 VDD VDD VSS VSS gf180mcu_fd_sc_mcu7t5v0__fill_1
XTAP_TAPCELL_ROW_33_450 VDD VSS gf180mcu_fd_sc_mcu7t5v0__filltie
XFILLER_50_263 VDD VDD VSS VSS gf180mcu_fd_sc_mcu7t5v0__fillcap_4
X_3969_ _3969_/D _4170_/CLK _3969_/Q VDD VDD VSS VSS gf180mcu_fd_sc_mcu7t5v0__dffq_1
XFILLER_12_45 VDD VDD VSS VSS gf180mcu_fd_sc_mcu7t5v0__fillcap_4
XFILLER_5_6 VDD VDD VSS VSS gf180mcu_fd_sc_mcu7t5v0__fill_1
Xhold150 _3932_/Q _2013_/I VDD VDD VSS VSS gf180mcu_fd_sc_mcu7t5v0__dlyc_1
XFILLER_88_49 VDD VDD VSS VSS gf180mcu_fd_sc_mcu7t5v0__fillcap_8
Xhold161 _4044_/Q hold161/Z VDD VDD VSS VSS gf180mcu_fd_sc_mcu7t5v0__dlyc_1
Xhold172 _4110_/Q _1890_/I VDD VDD VSS VSS gf180mcu_fd_sc_mcu7t5v0__dlyc_1
Xhold183 _4010_/Q _1935_/I VDD VDD VSS VSS gf180mcu_fd_sc_mcu7t5v0__dlyc_1
Xhold194 _4062_/Q hold194/Z VDD VDD VSS VSS gf180mcu_fd_sc_mcu7t5v0__dlyc_1
XFILLER_77_116 VDD VDD VSS VSS gf180mcu_fd_sc_mcu7t5v0__fill_1
XFILLER_77_138 VDD VDD VSS VSS gf180mcu_fd_sc_mcu7t5v0__fill_2
XFILLER_33_208 VDD VDD VSS VSS gf180mcu_fd_sc_mcu7t5v0__fill_2
Xclkbuf_1_1__f__1533_ clkbuf_0__1533_/Z _3540_/A2 VDD VDD VSS VSS gf180mcu_fd_sc_mcu7t5v0__clkbuf_16
XTAP_TAPCELL_ROW_56_586 VDD VSS gf180mcu_fd_sc_mcu7t5v0__filltie
XFILLER_41_274 VDD VDD VSS VSS gf180mcu_fd_sc_mcu7t5v0__fillcap_4
XFILLER_78_82 VDD VDD VSS VSS gf180mcu_fd_sc_mcu7t5v0__fillcap_8
XFILLER_76_171 VDD VDD VSS VSS gf180mcu_fd_sc_mcu7t5v0__fillcap_4
XFILLER_94_81 VDD VDD VSS VSS gf180mcu_fd_sc_mcu7t5v0__fillcap_8
XFILLER_17_282 VDD VDD VSS VSS gf180mcu_fd_sc_mcu7t5v0__fillcap_16
XFILLER_91_174 VDD VDD VSS VSS gf180mcu_fd_sc_mcu7t5v0__fillcap_16
X_3823_ _3823_/D _4021_/CLK _3823_/Q VDD VDD VSS VSS gf180mcu_fd_sc_mcu7t5v0__dffq_1
XFILLER_20_425 VDD VDD VSS VSS gf180mcu_fd_sc_mcu7t5v0__fill_1
XTAP_TAPCELL_ROW_30_431 VDD VSS gf180mcu_fd_sc_mcu7t5v0__filltie
X_3754_ _4198_/I _3754_/I1 _3757_/S _4153_/D VDD VDD VSS VSS gf180mcu_fd_sc_mcu7t5v0__mux2_2
XFILLER_118_346 VDD VDD VSS VSS gf180mcu_fd_sc_mcu7t5v0__fillcap_16
X_2705_ _3944_/Q _3886_/Q _2710_/A2 VDD VDD VSS VSS gf180mcu_fd_sc_mcu7t5v0__nor2_1
X_3685_ _4126_/Q _3678_/Z _3746_/B _3686_/A2 VDD VDD VSS VSS gf180mcu_fd_sc_mcu7t5v0__oai21_1
X_2636_ _3245_/A1 _3894_/Q _3893_/Q _3243_/A1 _2637_/B VDD VDD VSS VSS gf180mcu_fd_sc_mcu7t5v0__aoi22_1
X_2567_ _2561_/C _2567_/A2 _2568_/C VDD VDD VSS VSS gf180mcu_fd_sc_mcu7t5v0__nor2_1
X_2498_ _2498_/I0 hold165/Z _2498_/S _3870_/D VDD VDD VSS VSS gf180mcu_fd_sc_mcu7t5v0__mux2_2
XFILLER_101_279 VDD VDD VSS VSS gf180mcu_fd_sc_mcu7t5v0__fill_1
X_4168_ _4168_/D _4170_/CLK _4168_/Q VDD VDD VSS VSS gf180mcu_fd_sc_mcu7t5v0__dffq_1
X_3119_ _3119_/A1 _3121_/A2 _3119_/B _3957_/D VDD VDD VSS VSS gf180mcu_fd_sc_mcu7t5v0__aoi21_1
X_4099_ _4099_/D clkload3/I _4099_/Q VDD VDD VSS VSS gf180mcu_fd_sc_mcu7t5v0__dffq_1
XFILLER_82_163 VDD VDD VSS VSS gf180mcu_fd_sc_mcu7t5v0__fill_2
XFILLER_23_230 VDD VDD VSS VSS gf180mcu_fd_sc_mcu7t5v0__fillcap_4
XFILLER_70_358 VDD VDD VSS VSS gf180mcu_fd_sc_mcu7t5v0__fill_2
XFILLER_65_119 VDD VDD VSS VSS gf180mcu_fd_sc_mcu7t5v0__fillcap_16
XFILLER_48_96 VDD VDD VSS VSS gf180mcu_fd_sc_mcu7t5v0__fill_1
XFILLER_61_303 VDD VDD VSS VSS gf180mcu_fd_sc_mcu7t5v0__fill_2
XFILLER_104_91 VDD VDD VSS VSS gf180mcu_fd_sc_mcu7t5v0__fillcap_8
XFILLER_14_296 VDD VDD VSS VSS gf180mcu_fd_sc_mcu7t5v0__fillcap_8
XFILLER_115_349 VDD VDD VSS VSS gf180mcu_fd_sc_mcu7t5v0__fill_1
X_3470_ _4082_/Q _4081_/Q _4080_/Q _3475_/A2 VDD VDD VSS VSS gf180mcu_fd_sc_mcu7t5v0__nand3_1
X_2421_ _2421_/I _3854_/D VDD VDD VSS VSS gf180mcu_fd_sc_mcu7t5v0__clkinv_1
XFILLER_43_4 VDD VDD VSS VSS gf180mcu_fd_sc_mcu7t5v0__fill_1
X_2352_ _2362_/C _2352_/A2 _3821_/D VDD VDD VSS VSS gf180mcu_fd_sc_mcu7t5v0__nor2_1
XFILLER_96_200 VDD VDD VSS VSS gf180mcu_fd_sc_mcu7t5v0__fillcap_8
X_2283_ _3860_/Q _3830_/Q _2283_/Z VDD VDD VSS VSS gf180mcu_fd_sc_mcu7t5v0__xor2_1
XFILLER_29_2 VDD VDD VSS VSS gf180mcu_fd_sc_mcu7t5v0__fillcap_16
XFILLER_96_244 VDD VDD VSS VSS gf180mcu_fd_sc_mcu7t5v0__fill_1
X_4022_ _4022_/D clkload9/I _4022_/Q VDD VDD VSS VSS gf180mcu_fd_sc_mcu7t5v0__dffq_1
XFILLER_64_174 VDD VDD VSS VSS gf180mcu_fd_sc_mcu7t5v0__fill_1
X_3806_ _3806_/D _4021_/CLK _3806_/Q VDD VDD VSS VSS gf180mcu_fd_sc_mcu7t5v0__dffq_1
XFILLER_20_299 VDD VDD VSS VSS gf180mcu_fd_sc_mcu7t5v0__fillcap_4
X_1998_ _3947_/Q _3098_/A1 VDD VDD VSS VSS gf180mcu_fd_sc_mcu7t5v0__clkinv_1
X_3737_ hold139/Z _3725_/Z _3739_/A1 VDD VDD VSS VSS gf180mcu_fd_sc_mcu7t5v0__nor2_1
X_3668_ _3668_/A1 _3668_/A2 _3669_/B2 VDD VDD VSS VSS gf180mcu_fd_sc_mcu7t5v0__nand2_1
XFILLER_121_308 VDD VDD VSS VSS gf180mcu_fd_sc_mcu7t5v0__fillcap_32
X_2619_ _2619_/A1 _2619_/A2 _2619_/B _2619_/C _2625_/A1 VDD VDD VSS VSS gf180mcu_fd_sc_mcu7t5v0__oai211_1
X_3599_ _4148_/Q _3748_/A1 _3667_/A2 _4132_/Q _3603_/A1 VDD VDD VSS VSS gf180mcu_fd_sc_mcu7t5v0__aoi22_1
XFILLER_55_152 VDD VDD VSS VSS gf180mcu_fd_sc_mcu7t5v0__fillcap_4
XFILLER_70_177 VDD VDD VSS VSS gf180mcu_fd_sc_mcu7t5v0__fillcap_16
XFILLER_70_166 VDD VDD VSS VSS gf180mcu_fd_sc_mcu7t5v0__fill_1
XFILLER_109_132 VDD VDD VSS VSS gf180mcu_fd_sc_mcu7t5v0__fill_2
XFILLER_50_53 VDD VDD VSS VSS gf180mcu_fd_sc_mcu7t5v0__fill_2
XFILLER_120_374 VDD VDD VSS VSS gf180mcu_fd_sc_mcu7t5v0__fillcap_8
XTAP_TAPCELL_ROW_89_784 VDD VSS gf180mcu_fd_sc_mcu7t5v0__filltie
XFILLER_46_141 VDD VDD VSS VSS gf180mcu_fd_sc_mcu7t5v0__fill_2
XFILLER_75_61 VDD VDD VSS VSS gf180mcu_fd_sc_mcu7t5v0__fill_1
XFILLER_34_369 VDD VDD VSS VSS gf180mcu_fd_sc_mcu7t5v0__fill_2
X_2970_ _4018_/Q _3036_/A2 _3139_/A1 _3970_/Q _2973_/A1 VDD VDD VSS VSS gf180mcu_fd_sc_mcu7t5v0__aoi22_1
XTAP_TAPCELL_ROW_72_684 VDD VSS gf180mcu_fd_sc_mcu7t5v0__filltie
X_1921_ _4024_/Q _3262_/A1 VDD VDD VSS VSS gf180mcu_fd_sc_mcu7t5v0__clkinv_1
X_3522_ _4094_/Q _3527_/B _3536_/A2 _3522_/B2 _3523_/B VDD VDD VSS VSS gf180mcu_fd_sc_mcu7t5v0__aoi22_1
X_3453_ _3453_/A1 _3453_/A2 _3453_/B _3549_/A1 VDD VDD VSS VSS gf180mcu_fd_sc_mcu7t5v0__oai21_1
X_2404_ _3846_/Q wire51/Z _2404_/B _2405_/I VDD VDD VSS VSS gf180mcu_fd_sc_mcu7t5v0__aoi21_1
XFILLER_111_330 VDD VDD VSS VSS gf180mcu_fd_sc_mcu7t5v0__fill_1
X_3384_ _4137_/Q _3384_/A2 _4074_/Q _3707_/A1 _3384_/C _3386_/A3 VDD VDD VSS VSS gf180mcu_fd_sc_mcu7t5v0__aoi221_1
XFILLER_111_341 VDD VDD VSS VSS gf180mcu_fd_sc_mcu7t5v0__fill_2
X_2335_ _2339_/A2 _2338_/A1 _2335_/B _2335_/C _2336_/A2 VDD VDD VSS VSS gf180mcu_fd_sc_mcu7t5v0__aoi211_1
XFILLER_57_417 VDD VDD VSS VSS gf180mcu_fd_sc_mcu7t5v0__fill_2
X_2266_ _3821_/Q _2470_/A1 _2266_/B _2271_/A1 VDD VDD VSS VSS gf180mcu_fd_sc_mcu7t5v0__aoi21_1
XFILLER_84_236 VDD VDD VSS VSS gf180mcu_fd_sc_mcu7t5v0__fill_1
X_2197_ _4084_/Q _2248_/A2 _2199_/A1 VDD VDD VSS VSS gf180mcu_fd_sc_mcu7t5v0__nor2_1
X_4005_ _4005_/D _4166_/CLK _4005_/Q VDD VDD VSS VSS gf180mcu_fd_sc_mcu7t5v0__dffq_1
XFILLER_25_314 VDD VDD VSS VSS gf180mcu_fd_sc_mcu7t5v0__fillcap_4
XFILLER_37_185 VDD VDD VSS VSS gf180mcu_fd_sc_mcu7t5v0__fillcap_16
XFILLER_40_317 VDD VDD VSS VSS gf180mcu_fd_sc_mcu7t5v0__fill_1
XFILLER_52_177 VDD VDD VSS VSS gf180mcu_fd_sc_mcu7t5v0__fillcap_4
XFILLER_106_135 VDD VDD VSS VSS gf180mcu_fd_sc_mcu7t5v0__fillcap_8
XFILLER_106_168 VDD VDD VSS VSS gf180mcu_fd_sc_mcu7t5v0__fillcap_4
XFILLER_121_138 VDD VDD VSS VSS gf180mcu_fd_sc_mcu7t5v0__fillcap_8
XFILLER_29_32 VDD VDD VSS VSS gf180mcu_fd_sc_mcu7t5v0__fill_1
XFILLER_29_65 VDD VDD VSS VSS gf180mcu_fd_sc_mcu7t5v0__fillcap_4
XTAP_TAPCELL_ROW_3_273 VDD VSS gf180mcu_fd_sc_mcu7t5v0__filltie
XFILLER_45_53 VDD VDD VSS VSS gf180mcu_fd_sc_mcu7t5v0__fillcap_4
XFILLER_31_306 VDD VDD VSS VSS gf180mcu_fd_sc_mcu7t5v0__fill_1
XFILLER_3_284 VDD VDD VSS VSS gf180mcu_fd_sc_mcu7t5v0__fill_1
X_2120_ _3760_/Q _2243_/A2 _3746_/B _2121_/A2 VDD VDD VSS VSS gf180mcu_fd_sc_mcu7t5v0__oai21_1
XFILLER_86_82 VDD VDD VSS VSS gf180mcu_fd_sc_mcu7t5v0__fillcap_16
X_2051_ _3909_/Q _2669_/A2 VDD VDD VSS VSS gf180mcu_fd_sc_mcu7t5v0__clkinv_1
XFILLER_22_306 VDD VDD VSS VSS gf180mcu_fd_sc_mcu7t5v0__fill_1
XTAP_TAPCELL_ROW_17_353 VDD VSS gf180mcu_fd_sc_mcu7t5v0__filltie
X_2953_ _2954_/A1 _3597_/A2 _2987_/B1 VDD VDD VSS VSS gf180mcu_fd_sc_mcu7t5v0__nor2_1
XTAP_TAPCELL_ROW_60_610 VDD VSS gf180mcu_fd_sc_mcu7t5v0__filltie
XFILLER_96_2 VDD VDD VSS VSS gf180mcu_fd_sc_mcu7t5v0__fill_2
X_1904_ _4067_/Q _3385_/B1 VDD VDD VSS VSS gf180mcu_fd_sc_mcu7t5v0__clkinv_1
X_2884_ _2884_/A1 _2881_/Z _2884_/B _2884_/C _2890_/B VDD VDD VSS VSS gf180mcu_fd_sc_mcu7t5v0__aoi211_1
XFILLER_116_411 VDD VDD VSS VSS gf180mcu_fd_sc_mcu7t5v0__fillcap_8
X_3505_ _4090_/Q _3513_/A2 _3536_/A2 _3510_/A2 _3506_/B VDD VDD VSS VSS gf180mcu_fd_sc_mcu7t5v0__aoi22_1
X_3436_ _4078_/Q _3433_/Z _3436_/Z VDD VDD VSS VSS gf180mcu_fd_sc_mcu7t5v0__and2_1
XFILLER_103_138 VDD VDD VSS VSS gf180mcu_fd_sc_mcu7t5v0__fill_2
X_3367_ _3363_/B _3366_/Z _4062_/D VDD VDD VSS VSS gf180mcu_fd_sc_mcu7t5v0__nor2_1
XFILLER_106_37 VDD VDD VSS VSS gf180mcu_fd_sc_mcu7t5v0__fillcap_32
X_2318_ _4158_/Q _2252_/Z _2333_/B _2320_/B VDD VDD VSS VSS gf180mcu_fd_sc_mcu7t5v0__nand3_1
XFILLER_57_269 VDD VDD VSS VSS gf180mcu_fd_sc_mcu7t5v0__fill_1
X_3298_ _4040_/Q _3295_/Z _3300_/A2 VDD VDD VSS VSS gf180mcu_fd_sc_mcu7t5v0__nor2_1
X_2249_ _3805_/Q _2111_/Z _3746_/B _2250_/A2 VDD VDD VSS VSS gf180mcu_fd_sc_mcu7t5v0__oai21_1
XFILLER_72_217 VDD VDD VSS VSS gf180mcu_fd_sc_mcu7t5v0__fill_2
XTAP_TAPCELL_ROW_0_254 VDD VSS gf180mcu_fd_sc_mcu7t5v0__filltie
XPHY_EDGE_ROW_69_Left_191 VDD VSS gf180mcu_fd_sc_mcu7t5v0__endcap
XFILLER_15_67 VDD VDD VSS VSS gf180mcu_fd_sc_mcu7t5v0__fill_2
XTAP_TAPCELL_ROW_23_389 VDD VSS gf180mcu_fd_sc_mcu7t5v0__filltie
XFILLER_31_22 VDD VDD VSS VSS gf180mcu_fd_sc_mcu7t5v0__fill_1
XFILLER_107_400 VDD VDD VSS VSS gf180mcu_fd_sc_mcu7t5v0__fillcap_16
XFILLER_107_422 VDD VDD VSS VSS gf180mcu_fd_sc_mcu7t5v0__fillcap_4
Xoutput22 _4197_/Z bypass_pin_control[2] VDD VDD VSS VSS gf180mcu_fd_sc_mcu7t5v0__dlyb_1
Xoutput11 _3068_/A1 PAD_IE[1] VDD VDD VSS VSS gf180mcu_fd_sc_mcu7t5v0__dlyb_1
Xoutput9 _3931_/Q PAD_CS[1] VDD VDD VSS VSS gf180mcu_fd_sc_mcu7t5v0__dlyb_1
XFILLER_56_96 VDD VDD VSS VSS gf180mcu_fd_sc_mcu7t5v0__fillcap_8
XFILLER_56_291 VDD VDD VSS VSS gf180mcu_fd_sc_mcu7t5v0__fillcap_4
XTAP_TAPCELL_ROW_14_334 VDD VSS gf180mcu_fd_sc_mcu7t5v0__filltie
XFILLER_31_136 VDD VDD VSS VSS gf180mcu_fd_sc_mcu7t5v0__fillcap_4
XFILLER_8_387 VDD VDD VSS VSS gf180mcu_fd_sc_mcu7t5v0__fillcap_32
X_3221_ _3221_/A1 _3223_/A2 _3221_/B _4005_/D VDD VDD VSS VSS gf180mcu_fd_sc_mcu7t5v0__aoi21_1
XTAP_TAPCELL_ROW_109_906 VDD VSS gf180mcu_fd_sc_mcu7t5v0__filltie
X_3152_ _3288_/A1 _3155_/A2 wire81/Z _3153_/B VDD VDD VSS VSS gf180mcu_fd_sc_mcu7t5v0__oai21_1
XFILLER_79_372 VDD VDD VSS VSS gf180mcu_fd_sc_mcu7t5v0__fillcap_4
XFILLER_11_2 VDD VDD VSS VSS gf180mcu_fd_sc_mcu7t5v0__fill_2
X_2103_ _3837_/Q _2105_/A1 _3664_/B1 VDD VDD VSS VSS gf180mcu_fd_sc_mcu7t5v0__nor2_1
XFILLER_27_409 VDD VDD VSS VSS gf180mcu_fd_sc_mcu7t5v0__fillcap_8
X_3083_ _3083_/A1 _3241_/A2 _3087_/A2 VDD VDD VSS VSS gf180mcu_fd_sc_mcu7t5v0__nand2_1
X_2034_ _3834_/Q _2363_/A2 VDD VDD VSS VSS gf180mcu_fd_sc_mcu7t5v0__clkinv_1
XFILLER_62_272 VDD VDD VSS VSS gf180mcu_fd_sc_mcu7t5v0__fill_2
X_3985_ _3985_/D clkload1/I _3985_/Q VDD VDD VSS VSS gf180mcu_fd_sc_mcu7t5v0__dffq_1
X_2936_ _3846_/Q _2936_/A2 _2934_/Z _2999_/B1 VDD VDD VSS VSS gf180mcu_fd_sc_mcu7t5v0__nor3_1
X_2867_ _3967_/Q _3909_/Q _2881_/A1 VDD VDD VSS VSS gf180mcu_fd_sc_mcu7t5v0__nand2_1
XTAP_TAPCELL_ROW_100_850 VDD VSS gf180mcu_fd_sc_mcu7t5v0__filltie
X_2798_ _2798_/A1 _2798_/A2 _2791_/B _2802_/A4 _2805_/A3 VDD VDD VSS VSS gf180mcu_fd_sc_mcu7t5v0__nor4_1
X_3419_ _3401_/I _3419_/A2 _3418_/Z _4071_/D VDD VDD VSS VSS gf180mcu_fd_sc_mcu7t5v0__nor3_1
XTAP_TAPCELL_ROW_36_470 VDD VSS gf180mcu_fd_sc_mcu7t5v0__filltie
XFILLER_13_136 VDD VDD VSS VSS gf180mcu_fd_sc_mcu7t5v0__fillcap_4
XFILLER_42_98 VDD VDD VSS VSS gf180mcu_fd_sc_mcu7t5v0__fillcap_4
XFILLER_107_230 VDD VDD VSS VSS gf180mcu_fd_sc_mcu7t5v0__fill_2
XTAP_TAPCELL_ROW_94_819 VDD VSS gf180mcu_fd_sc_mcu7t5v0__filltie
XFILLER_91_334 VDD VDD VSS VSS gf180mcu_fd_sc_mcu7t5v0__fill_2
XFILLER_83_50 VDD VDD VSS VSS gf180mcu_fd_sc_mcu7t5v0__fill_1
XFILLER_32_401 VDD VDD VSS VSS gf180mcu_fd_sc_mcu7t5v0__fillcap_16
XFILLER_44_283 VDD VDD VSS VSS gf180mcu_fd_sc_mcu7t5v0__fill_2
XFILLER_83_72 VDD VDD VSS VSS gf180mcu_fd_sc_mcu7t5v0__fillcap_4
XFILLER_44_294 VDD VDD VSS VSS gf180mcu_fd_sc_mcu7t5v0__fillcap_4
X_3770_ _3770_/D _4052_/CLK _3770_/Q VDD VDD VSS VSS gf180mcu_fd_sc_mcu7t5v0__dffq_1
X_2721_ _2749_/A1 _2749_/A2 _2721_/Z VDD VDD VSS VSS gf180mcu_fd_sc_mcu7t5v0__or2_1
XFILLER_8_195 VDD VDD VSS VSS gf180mcu_fd_sc_mcu7t5v0__fillcap_8
X_2652_ _3274_/A1 _3908_/Q _2653_/B VDD VDD VSS VSS gf180mcu_fd_sc_mcu7t5v0__nor2_1
X_2583_ _3990_/Q _2640_/A2 _2599_/A1 VDD VDD VSS VSS gf180mcu_fd_sc_mcu7t5v0__nor2_1
XFILLER_59_2 VDD VDD VSS VSS gf180mcu_fd_sc_mcu7t5v0__fill_1
X_3204_ _3204_/A1 _3206_/A2 _3204_/B _3997_/D VDD VDD VSS VSS gf180mcu_fd_sc_mcu7t5v0__aoi21_1
X_3135_ _3288_/A1 _3136_/A2 wire81/Z _3136_/B VDD VDD VSS VSS gf180mcu_fd_sc_mcu7t5v0__oai21_1
X_3066_ _3066_/A1 _3082_/A2 _3066_/B _3932_/D VDD VDD VSS VSS gf180mcu_fd_sc_mcu7t5v0__aoi21_1
X_2017_ _2017_/I _2552_/A1 VDD VDD VSS VSS gf180mcu_fd_sc_mcu7t5v0__clkinv_1
XTAP_TAPCELL_ROW_33_451 VDD VSS gf180mcu_fd_sc_mcu7t5v0__filltie
X_3968_ _3968_/D _4170_/CLK _3968_/Q VDD VDD VSS VSS gf180mcu_fd_sc_mcu7t5v0__dffq_1
XFILLER_50_297 VDD VDD VSS VSS gf180mcu_fd_sc_mcu7t5v0__fill_1
X_2919_ _2920_/A1 _2920_/A2 _2919_/B _2921_/A2 VDD VDD VSS VSS gf180mcu_fd_sc_mcu7t5v0__aoi21_1
X_3899_ _3899_/D clkload8/I _3899_/Q VDD VDD VSS VSS gf180mcu_fd_sc_mcu7t5v0__dffq_1
XFILLER_88_17 VDD VDD VSS VSS gf180mcu_fd_sc_mcu7t5v0__fillcap_8
Xhold151 _3920_/Q hold151/Z VDD VDD VSS VSS gf180mcu_fd_sc_mcu7t5v0__dlyc_1
Xhold140 _4119_/Q hold140/Z VDD VDD VSS VSS gf180mcu_fd_sc_mcu7t5v0__dlyc_1
Xhold162 hold162/I _3763_/D VDD VDD VSS VSS gf180mcu_fd_sc_mcu7t5v0__dlyc_1
Xhold184 _4122_/Q hold184/Z VDD VDD VSS VSS gf180mcu_fd_sc_mcu7t5v0__dlyc_1
Xhold195 hold195/I _3781_/D VDD VDD VSS VSS gf180mcu_fd_sc_mcu7t5v0__dlyc_1
Xhold173 _4002_/Q _1943_/I VDD VDD VSS VSS gf180mcu_fd_sc_mcu7t5v0__dlyc_1
Xclkbuf_1_1__f__1532_ clkbuf_0__1532_/Z _3541_/A2 VDD VDD VSS VSS gf180mcu_fd_sc_mcu7t5v0__clkbuf_16
XFILLER_14_423 VDD VDD VSS VSS gf180mcu_fd_sc_mcu7t5v0__fill_2
XTAP_TAPCELL_ROW_56_587 VDD VSS gf180mcu_fd_sc_mcu7t5v0__filltie
XFILLER_41_220 VDD VDD VSS VSS gf180mcu_fd_sc_mcu7t5v0__fill_2
XFILLER_53_86 VDD VDD VSS VSS gf180mcu_fd_sc_mcu7t5v0__fill_1
XFILLER_64_301 VDD VDD VSS VSS gf180mcu_fd_sc_mcu7t5v0__fillcap_8
XTAP_TAPCELL_ROW_47_532 VDD VSS gf180mcu_fd_sc_mcu7t5v0__filltie
XFILLER_91_142 VDD VDD VSS VSS gf180mcu_fd_sc_mcu7t5v0__fillcap_32
X_3822_ _3822_/D _4021_/CLK _3822_/Q VDD VDD VSS VSS gf180mcu_fd_sc_mcu7t5v0__dffq_1
XFILLER_118_314 VDD VDD VSS VSS gf180mcu_fd_sc_mcu7t5v0__fill_1
XTAP_TAPCELL_ROW_30_432 VDD VSS gf180mcu_fd_sc_mcu7t5v0__filltie
X_3753_ _4197_/I wire90/Z _3757_/S _4152_/D VDD VDD VSS VSS gf180mcu_fd_sc_mcu7t5v0__mux2_2
X_2704_ _3944_/Q _3886_/Q _2710_/B VDD VDD VSS VSS gf180mcu_fd_sc_mcu7t5v0__nand2_1
X_3684_ _3751_/I1 _3692_/A2 _3686_/A1 VDD VDD VSS VSS gf180mcu_fd_sc_mcu7t5v0__nor2_1
X_2635_ _3243_/A1 _3893_/Q _3892_/Q _3240_/A1 _2637_/A2 VDD VDD VSS VSS gf180mcu_fd_sc_mcu7t5v0__oai22_1
XFILLER_99_220 VDD VDD VSS VSS gf180mcu_fd_sc_mcu7t5v0__fill_2
X_2566_ _3996_/Q _2845_/A2 _2844_/A2 _3995_/Q _2601_/A3 VDD VDD VSS VSS gf180mcu_fd_sc_mcu7t5v0__oai22_1
XFILLER_99_231 VDD VDD VSS VSS gf180mcu_fd_sc_mcu7t5v0__fillcap_16
X_2497_ _2497_/A1 _2497_/A2 _2498_/I0 VDD VDD VSS VSS gf180mcu_fd_sc_mcu7t5v0__nand2_1
XFILLER_59_117 VDD VDD VSS VSS gf180mcu_fd_sc_mcu7t5v0__fill_2
XFILLER_59_139 VDD VDD VSS VSS gf180mcu_fd_sc_mcu7t5v0__fill_1
XFILLER_114_37 VDD VDD VSS VSS gf180mcu_fd_sc_mcu7t5v0__fillcap_8
XFILLER_114_26 VDD VDD VSS VSS gf180mcu_fd_sc_mcu7t5v0__fillcap_8
X_4167_ _4167_/D _4169_/CLK _4167_/Q VDD VDD VSS VSS gf180mcu_fd_sc_mcu7t5v0__dffq_1
XFILLER_101_269 VDD VDD VSS VSS gf180mcu_fd_sc_mcu7t5v0__fill_1
X_3118_ _3288_/A1 _3121_/A2 _3256_/B _3119_/B VDD VDD VSS VSS gf180mcu_fd_sc_mcu7t5v0__oai21_1
X_4098_ _4098_/D clkload3/I _4098_/Q VDD VDD VSS VSS gf180mcu_fd_sc_mcu7t5v0__dffq_1
XFILLER_15_209 VDD VDD VSS VSS gf180mcu_fd_sc_mcu7t5v0__fill_1
X_3049_ hold188/Z _3676_/A2 _3049_/B1 _3275_/A2 _3050_/A2 VDD VDD VSS VSS gf180mcu_fd_sc_mcu7t5v0__aoi22_1
XFILLER_82_197 VDD VDD VSS VSS gf180mcu_fd_sc_mcu7t5v0__fillcap_4
XTAP_TAPCELL_ROW_53_568 VDD VSS gf180mcu_fd_sc_mcu7t5v0__filltie
XFILLER_23_297 VDD VDD VSS VSS gf180mcu_fd_sc_mcu7t5v0__fillcap_8
XFILLER_23_275 VDD VDD VSS VSS gf180mcu_fd_sc_mcu7t5v0__fillcap_4
XFILLER_3_4 VDD VDD VSS VSS gf180mcu_fd_sc_mcu7t5v0__fill_1
XFILLER_48_31 VDD VDD VSS VSS gf180mcu_fd_sc_mcu7t5v0__fillcap_4
XFILLER_0_38 VDD VDD VSS VSS gf180mcu_fd_sc_mcu7t5v0__fill_1
XFILLER_73_120 VDD VDD VSS VSS gf180mcu_fd_sc_mcu7t5v0__fillcap_4
XFILLER_64_63 VDD VDD VSS VSS gf180mcu_fd_sc_mcu7t5v0__fillcap_8
XPHY_EDGE_ROW_14_Left_136 VDD VSS gf180mcu_fd_sc_mcu7t5v0__endcap
XFILLER_9_14 VDD VDD VSS VSS gf180mcu_fd_sc_mcu7t5v0__fill_2
X_2420_ _3290_/A1 wire51/I wire77/Z _3814_/Q _2421_/I VDD VDD VSS VSS gf180mcu_fd_sc_mcu7t5v0__aoi22_1
XPHY_EDGE_ROW_23_Left_145 VDD VSS gf180mcu_fd_sc_mcu7t5v0__endcap
XFILLER_50_6 VDD VDD VSS VSS gf180mcu_fd_sc_mcu7t5v0__fill_1
X_2351_ _3821_/Q _2361_/A2 _2351_/B _2352_/A2 VDD VDD VSS VSS gf180mcu_fd_sc_mcu7t5v0__oai21_1
XFILLER_69_415 VDD VDD VSS VSS gf180mcu_fd_sc_mcu7t5v0__fillcap_4
X_2282_ _3857_/Q _3827_/Q _2282_/Z VDD VDD VSS VSS gf180mcu_fd_sc_mcu7t5v0__xor2_1
X_4021_ _4021_/D _4021_/CLK _4021_/Q VDD VDD VSS VSS gf180mcu_fd_sc_mcu7t5v0__dffq_1
XFILLER_56_109 VDD VDD VSS VSS gf180mcu_fd_sc_mcu7t5v0__fill_1
XPHY_EDGE_ROW_32_Left_154 VDD VSS gf180mcu_fd_sc_mcu7t5v0__endcap
XFILLER_60_381 VDD VDD VSS VSS gf180mcu_fd_sc_mcu7t5v0__fillcap_4
X_1997_ _3948_/Q _3100_/A1 VDD VDD VSS VSS gf180mcu_fd_sc_mcu7t5v0__clkinv_1
X_3805_ _3805_/D _4104_/CLK _3805_/Q VDD VDD VSS VSS gf180mcu_fd_sc_mcu7t5v0__dffq_1
X_3736_ _3736_/A1 _3736_/A2 _4143_/D VDD VDD VSS VSS gf180mcu_fd_sc_mcu7t5v0__nor2_1
XFILLER_118_166 VDD VDD VSS VSS gf180mcu_fd_sc_mcu7t5v0__fill_1
XPHY_EDGE_ROW_41_Left_163 VDD VSS gf180mcu_fd_sc_mcu7t5v0__endcap
XFILLER_118_177 VDD VDD VSS VSS gf180mcu_fd_sc_mcu7t5v0__fillcap_4
X_3667_ _4139_/Q _3667_/A2 _3679_/A1 _4131_/Q _3667_/C1 _3667_/C2 _3668_/A2 VDD VDD
+ VSS VSS gf180mcu_fd_sc_mcu7t5v0__aoi222_1
XFILLER_106_317 VDD VDD VSS VSS gf180mcu_fd_sc_mcu7t5v0__fill_2
X_3598_ _3674_/B _2943_/Z _3667_/A2 VDD VDD VSS VSS gf180mcu_fd_sc_mcu7t5v0__nor2_1
X_2618_ _2620_/A1 _2618_/A2 _2618_/A3 _2619_/C VDD VDD VSS VSS gf180mcu_fd_sc_mcu7t5v0__nor3_1
X_2549_ _3882_/Q _2549_/A2 _2549_/B _2549_/C _2555_/B1 VDD VDD VSS VSS gf180mcu_fd_sc_mcu7t5v0__aoi211_1
XFILLER_87_212 VDD VDD VSS VSS gf180mcu_fd_sc_mcu7t5v0__fillcap_8
XFILLER_87_245 VDD VDD VSS VSS gf180mcu_fd_sc_mcu7t5v0__fillcap_16
XFILLER_87_278 VDD VDD VSS VSS gf180mcu_fd_sc_mcu7t5v0__fill_2
XFILLER_18_45 VDD VDD VSS VSS gf180mcu_fd_sc_mcu7t5v0__fillcap_8
XPHY_EDGE_ROW_50_Left_172 VDD VSS gf180mcu_fd_sc_mcu7t5v0__endcap
XFILLER_55_142 VDD VDD VSS VSS gf180mcu_fd_sc_mcu7t5v0__fill_1
XFILLER_28_378 VDD VDD VSS VSS gf180mcu_fd_sc_mcu7t5v0__fillcap_4
XFILLER_109_111 VDD VDD VSS VSS gf180mcu_fd_sc_mcu7t5v0__fill_1
XFILLER_7_249 VDD VDD VSS VSS gf180mcu_fd_sc_mcu7t5v0__fill_2
XFILLER_3_422 VDD VDD VSS VSS gf180mcu_fd_sc_mcu7t5v0__fillcap_4
XFILLER_112_309 VDD VDD VSS VSS gf180mcu_fd_sc_mcu7t5v0__fillcap_4
XFILLER_78_201 VDD VDD VSS VSS gf180mcu_fd_sc_mcu7t5v0__fill_1
XFILLER_78_278 VDD VDD VSS VSS gf180mcu_fd_sc_mcu7t5v0__fill_2
XTAP_TAPCELL_ROW_89_785 VDD VSS gf180mcu_fd_sc_mcu7t5v0__filltie
XTAP_TAPCELL_ROW_72_685 VDD VSS gf180mcu_fd_sc_mcu7t5v0__filltie
XFILLER_91_72 VDD VDD VSS VSS gf180mcu_fd_sc_mcu7t5v0__fillcap_8
X_1920_ _1920_/I _3264_/A1 VDD VDD VSS VSS gf180mcu_fd_sc_mcu7t5v0__clkinv_1
X_3521_ _4094_/Q _4093_/Q _3511_/Z _3522_/B2 VDD VDD VSS VSS gf180mcu_fd_sc_mcu7t5v0__nand3_1
XFILLER_6_271 VDD VDD VSS VSS gf180mcu_fd_sc_mcu7t5v0__fillcap_32
X_3452_ _4103_/Q _4102_/Q _4101_/Q _4100_/Q _3453_/B VDD VDD VSS VSS gf180mcu_fd_sc_mcu7t5v0__nor4_1
X_2403_ _3882_/Q _4157_/Q _2379_/Z wire77/I VDD VDD VSS VSS gf180mcu_fd_sc_mcu7t5v0__nor3_1
XFILLER_41_2 VDD VDD VSS VSS gf180mcu_fd_sc_mcu7t5v0__fill_2
X_3383_ _3376_/Z _3379_/Z _3383_/A3 _3383_/A4 _3387_/A3 VDD VDD VSS VSS gf180mcu_fd_sc_mcu7t5v0__nor4_1
XFILLER_111_320 VDD VDD VSS VSS gf180mcu_fd_sc_mcu7t5v0__fillcap_4
X_2334_ _3833_/Q _3834_/Q _2334_/B1 _2339_/A2 _2335_/C VDD VDD VSS VSS gf180mcu_fd_sc_mcu7t5v0__oai22_1
XFILLER_69_212 VDD VDD VSS VSS gf180mcu_fd_sc_mcu7t5v0__fill_2
XFILLER_111_375 VDD VDD VSS VSS gf180mcu_fd_sc_mcu7t5v0__fillcap_4
X_2265_ _3821_/Q _3864_/Q _3822_/Q _2266_/B VDD VDD VSS VSS gf180mcu_fd_sc_mcu7t5v0__oai21_1
X_2196_ _2196_/A1 _2196_/A2 _3785_/D VDD VDD VSS VSS gf180mcu_fd_sc_mcu7t5v0__nor2_1
X_4004_ _4004_/D _4169_/CLK _4004_/Q VDD VDD VSS VSS gf180mcu_fd_sc_mcu7t5v0__dffq_1
XTAP_TAPCELL_ROW_63_630 VDD VSS gf180mcu_fd_sc_mcu7t5v0__filltie
XFILLER_20_13 VDD VDD VSS VSS gf180mcu_fd_sc_mcu7t5v0__fillcap_16
X_3719_ _3719_/A1 _3719_/A2 _4139_/D VDD VDD VSS VSS gf180mcu_fd_sc_mcu7t5v0__nor2_1
XFILLER_20_46 VDD VDD VSS VSS gf180mcu_fd_sc_mcu7t5v0__fillcap_8
XFILLER_106_147 VDD VDD VSS VSS gf180mcu_fd_sc_mcu7t5v0__fill_2
XFILLER_75_248 VDD VDD VSS VSS gf180mcu_fd_sc_mcu7t5v0__fill_2
XTAP_TAPCELL_ROW_86_766 VDD VSS gf180mcu_fd_sc_mcu7t5v0__filltie
XFILLER_45_65 VDD VDD VSS VSS gf180mcu_fd_sc_mcu7t5v0__fillcap_4
XFILLER_43_156 VDD VDD VSS VSS gf180mcu_fd_sc_mcu7t5v0__fill_1
XFILLER_24_381 VDD VDD VSS VSS gf180mcu_fd_sc_mcu7t5v0__fillcap_4
XFILLER_61_20 VDD VDD VSS VSS gf180mcu_fd_sc_mcu7t5v0__fill_1
XFILLER_120_172 VDD VDD VSS VSS gf180mcu_fd_sc_mcu7t5v0__fill_2
X_2050_ _3910_/Q _2873_/A2 VDD VDD VSS VSS gf180mcu_fd_sc_mcu7t5v0__clkinv_1
XFILLER_19_142 VDD VDD VSS VSS gf180mcu_fd_sc_mcu7t5v0__fillcap_8
XTAP_TAPCELL_ROW_17_354 VDD VSS gf180mcu_fd_sc_mcu7t5v0__filltie
XFILLER_34_156 VDD VDD VSS VSS gf180mcu_fd_sc_mcu7t5v0__fill_1
XTAP_TAPCELL_ROW_60_611 VDD VSS gf180mcu_fd_sc_mcu7t5v0__filltie
X_2952_ _4001_/Q _3207_/A1 _3060_/A1 _3938_/Q _2961_/A1 VDD VDD VSS VSS gf180mcu_fd_sc_mcu7t5v0__aoi22_1
X_1903_ _4069_/Q _3385_/A2 VDD VDD VSS VSS gf180mcu_fd_sc_mcu7t5v0__clkinv_1
X_2883_ _2868_/Z _2885_/A1 _2883_/A3 _2894_/A1 VDD VDD VSS VSS gf180mcu_fd_sc_mcu7t5v0__nand3_1
XFILLER_30_362 VDD VDD VSS VSS gf180mcu_fd_sc_mcu7t5v0__fill_2
XFILLER_30_373 VDD VDD VSS VSS gf180mcu_fd_sc_mcu7t5v0__fill_1
XFILLER_116_423 VDD VDD VSS VSS gf180mcu_fd_sc_mcu7t5v0__fill_2
X_3504_ _4090_/Q _4089_/Q _3496_/Z _3510_/A2 VDD VDD VSS VSS gf180mcu_fd_sc_mcu7t5v0__nand3_1
X_3435_ _3433_/Z _3435_/A2 _4077_/D VDD VDD VSS VSS gf180mcu_fd_sc_mcu7t5v0__nor2_1
X_3366_ hold234/Z _3366_/A2 _3366_/Z VDD VDD VSS VSS gf180mcu_fd_sc_mcu7t5v0__xor2_1
X_2317_ _2362_/C _2317_/A2 _2314_/I _2317_/A4 _2321_/S VDD VDD VSS VSS gf180mcu_fd_sc_mcu7t5v0__nor4_1
X_3297_ _3363_/B _3295_/Z _3297_/A3 _4039_/D VDD VDD VSS VSS gf180mcu_fd_sc_mcu7t5v0__nor3_1
X_2248_ _4103_/Q _2248_/A2 _2250_/A1 VDD VDD VSS VSS gf180mcu_fd_sc_mcu7t5v0__nor2_1
XTAP_TAPCELL_ROW_0_244 VDD VSS gf180mcu_fd_sc_mcu7t5v0__filltie
X_2179_ _4061_/Q _2242_/A2 _2181_/A1 VDD VDD VSS VSS gf180mcu_fd_sc_mcu7t5v0__nor2_1
XTAP_TAPCELL_ROW_0_255 VDD VSS gf180mcu_fd_sc_mcu7t5v0__filltie
XFILLER_25_178 VDD VDD VSS VSS gf180mcu_fd_sc_mcu7t5v0__fill_2
XTAP_TAPCELL_ROW_103_870 VDD VSS gf180mcu_fd_sc_mcu7t5v0__filltie
XFILLER_31_34 VDD VDD VSS VSS gf180mcu_fd_sc_mcu7t5v0__fill_1
Xdelaybuf_2_signal_clock delaybuf_2_signal_clock/I clkbuf_0_signal_input/I VDD VDD
+ VSS VSS gf180mcu_fd_sc_mcu7t5v0__clkbuf_16
XTAP_TAPCELL_ROW_8_300 VDD VSS gf180mcu_fd_sc_mcu7t5v0__filltie
Xoutput23 _3806_/Q i2c_sda_out_pin_ctrl VDD VDD VSS VSS gf180mcu_fd_sc_mcu7t5v0__dlyb_1
Xoutput12 _3934_/Q PAD_OE[0] VDD VDD VSS VSS gf180mcu_fd_sc_mcu7t5v0__dlyb_1
XFILLER_48_215 VDD VDD VSS VSS gf180mcu_fd_sc_mcu7t5v0__fill_1
XFILLER_63_207 VDD VDD VSS VSS gf180mcu_fd_sc_mcu7t5v0__fill_2
XPHY_EDGE_ROW_113_Right_113 VDD VSS gf180mcu_fd_sc_mcu7t5v0__endcap
XFILLER_71_262 VDD VDD VSS VSS gf180mcu_fd_sc_mcu7t5v0__fillcap_8
XTAP_TAPCELL_ROW_14_335 VDD VSS gf180mcu_fd_sc_mcu7t5v0__filltie
XFILLER_8_311 VDD VDD VSS VSS gf180mcu_fd_sc_mcu7t5v0__fillcap_4
X_3220_ _3288_/A1 _3223_/A2 wire81/Z _3221_/B VDD VDD VSS VSS gf180mcu_fd_sc_mcu7t5v0__oai21_1
XFILLER_97_82 VDD VDD VSS VSS gf180mcu_fd_sc_mcu7t5v0__fillcap_4
XTAP_TAPCELL_ROW_109_907 VDD VSS gf180mcu_fd_sc_mcu7t5v0__filltie
X_3151_ _3151_/A1 _3151_/A2 _3151_/B _3972_/D VDD VDD VSS VSS gf180mcu_fd_sc_mcu7t5v0__aoi21_1
X_2102_ _2947_/A2 _2105_/A1 wire71/I VDD VDD VSS VSS gf180mcu_fd_sc_mcu7t5v0__nor2_1
XPHY_EDGE_ROW_6_Left_128 VDD VSS gf180mcu_fd_sc_mcu7t5v0__endcap
X_3082_ _3082_/A1 _3082_/A2 _3082_/B _3940_/D VDD VDD VSS VSS gf180mcu_fd_sc_mcu7t5v0__aoi21_1
X_2033_ _3884_/Q _2379_/A1 VDD VDD VSS VSS gf180mcu_fd_sc_mcu7t5v0__clkinv_1
X_3984_ _3984_/D clkload1/I _3984_/Q VDD VDD VSS VSS gf180mcu_fd_sc_mcu7t5v0__dffq_1
X_2935_ _3846_/Q _2934_/Z _3046_/B1 VDD VDD VSS VSS gf180mcu_fd_sc_mcu7t5v0__nor2_1
X_2866_ wire31/Z _2865_/Z _2866_/B _2897_/A1 VDD VDD VSS VSS gf180mcu_fd_sc_mcu7t5v0__oai21_1
XTAP_TAPCELL_ROW_100_851 VDD VSS gf180mcu_fd_sc_mcu7t5v0__filltie
X_2797_ _2760_/C _2797_/A2 _3900_/D VDD VDD VSS VSS gf180mcu_fd_sc_mcu7t5v0__nor2_1
Xtop_level_110 i2c_sda_out_pdrv_control[0] VDD VDD VSS VSS gf180mcu_fd_sc_mcu7t5v0__tieh
X_3418_ _4071_/Q _3414_/Z _3418_/Z VDD VDD VSS VSS gf180mcu_fd_sc_mcu7t5v0__and2_1
XFILLER_77_19 VDD VDD VSS VSS gf180mcu_fd_sc_mcu7t5v0__fill_2
X_3349_ _3349_/I _4056_/D VDD VDD VSS VSS gf180mcu_fd_sc_mcu7t5v0__clkinv_1
XFILLER_85_387 VDD VDD VSS VSS gf180mcu_fd_sc_mcu7t5v0__fillcap_4
XFILLER_38_292 VDD VDD VSS VSS gf180mcu_fd_sc_mcu7t5v0__fillcap_16
XTAP_TAPCELL_ROW_36_471 VDD VSS gf180mcu_fd_sc_mcu7t5v0__filltie
XFILLER_41_413 VDD VDD VSS VSS gf180mcu_fd_sc_mcu7t5v0__fillcap_4
XTAP_TAPCELL_ROW_11_316 VDD VSS gf180mcu_fd_sc_mcu7t5v0__filltie
XFILLER_3_38 VDD VDD VSS VSS gf180mcu_fd_sc_mcu7t5v0__fill_2
XFILLER_29_270 VDD VDD VSS VSS gf180mcu_fd_sc_mcu7t5v0__fill_1
XFILLER_76_387 VDD VDD VSS VSS gf180mcu_fd_sc_mcu7t5v0__fillcap_4
XFILLER_91_313 VDD VDD VSS VSS gf180mcu_fd_sc_mcu7t5v0__fillcap_8
XFILLER_44_240 VDD VDD VSS VSS gf180mcu_fd_sc_mcu7t5v0__fill_1
X_2720_ _3946_/Q _3888_/Q _2709_/Z _2720_/B2 _2720_/C _2749_/A2 VDD VDD VSS VSS gf180mcu_fd_sc_mcu7t5v0__aoi221_1
Xclkbuf_leaf_13_ext_clk_in clkbuf_leaf_1_ext_clk_in/I clkload3/I VDD VDD VSS VSS gf180mcu_fd_sc_mcu7t5v0__clkbuf_8
XFILLER_8_152 VDD VDD VSS VSS gf180mcu_fd_sc_mcu7t5v0__fill_2
X_2651_ _4037_/Q _2651_/A2 _2651_/B _2696_/A2 VDD VDD VSS VSS gf180mcu_fd_sc_mcu7t5v0__aoi21_1
XFILLER_8_174 VDD VDD VSS VSS gf180mcu_fd_sc_mcu7t5v0__fill_1
X_2582_ _3985_/Q _2776_/A2 _3894_/Q _3177_/A1 _2582_/C _2590_/B VDD VDD VSS VSS gf180mcu_fd_sc_mcu7t5v0__oai221_1
XFILLER_113_212 VDD VDD VSS VSS gf180mcu_fd_sc_mcu7t5v0__fillcap_16
X_3203_ _3853_/Q _3206_/A2 wire81/Z _3204_/B VDD VDD VSS VSS gf180mcu_fd_sc_mcu7t5v0__oai21_1
XFILLER_86_107 VDD VDD VSS VSS gf180mcu_fd_sc_mcu7t5v0__fillcap_16
XFILLER_27_207 VDD VDD VSS VSS gf180mcu_fd_sc_mcu7t5v0__fill_2
X_3134_ _3134_/A1 _3138_/A2 _3134_/B _3964_/D VDD VDD VSS VSS gf180mcu_fd_sc_mcu7t5v0__aoi21_1
X_3065_ _3848_/Q _3082_/A2 wire81/Z _3066_/B VDD VDD VSS VSS gf180mcu_fd_sc_mcu7t5v0__oai21_1
X_2016_ _3929_/Q _3059_/A1 VDD VDD VSS VSS gf180mcu_fd_sc_mcu7t5v0__clkinv_1
XFILLER_50_221 VDD VDD VSS VSS gf180mcu_fd_sc_mcu7t5v0__fillcap_8
X_3967_ _3967_/D _4170_/CLK _3967_/Q VDD VDD VSS VSS gf180mcu_fd_sc_mcu7t5v0__dffq_1
XFILLER_10_107 VDD VDD VSS VSS gf180mcu_fd_sc_mcu7t5v0__fill_1
XTAP_TAPCELL_ROW_33_452 VDD VSS gf180mcu_fd_sc_mcu7t5v0__filltie
XFILLER_10_129 VDD VDD VSS VSS gf180mcu_fd_sc_mcu7t5v0__fill_2
X_2918_ _2919_/B _2922_/B VDD VDD VSS VSS gf180mcu_fd_sc_mcu7t5v0__clkinv_1
X_3898_ _3898_/D clkload8/I _3898_/Q VDD VDD VSS VSS gf180mcu_fd_sc_mcu7t5v0__dffq_1
X_2849_ _3963_/Q _3905_/Q _2850_/A3 _2863_/B VDD VDD VSS VSS gf180mcu_fd_sc_mcu7t5v0__nand3_1
XFILLER_2_317 VDD VDD VSS VSS gf180mcu_fd_sc_mcu7t5v0__fillcap_64
Xhold130 _3868_/Q _2075_/I VDD VDD VSS VSS gf180mcu_fd_sc_mcu7t5v0__dlyc_1
Xhold152 _3975_/Q _1970_/I VDD VDD VSS VSS gf180mcu_fd_sc_mcu7t5v0__dlyc_1
Xhold141 _3921_/Q hold141/Z VDD VDD VSS VSS gf180mcu_fd_sc_mcu7t5v0__dlyc_1
Xhold174 _4107_/Q hold174/Z VDD VDD VSS VSS gf180mcu_fd_sc_mcu7t5v0__dlyc_1
Xhold185 _3865_/Q hold185/Z VDD VDD VSS VSS gf180mcu_fd_sc_mcu7t5v0__dlyc_1
Xhold163 _3802_/Q hold163/Z VDD VDD VSS VSS gf180mcu_fd_sc_mcu7t5v0__dlyc_1
Xhold196 _3776_/Q hold196/Z VDD VDD VSS VSS gf180mcu_fd_sc_mcu7t5v0__dlyc_1
XFILLER_58_321 VDD VDD VSS VSS gf180mcu_fd_sc_mcu7t5v0__fill_1
XFILLER_58_332 VDD VDD VSS VSS gf180mcu_fd_sc_mcu7t5v0__fill_1
XTAP_TAPCELL_ROW_56_588 VDD VSS gf180mcu_fd_sc_mcu7t5v0__filltie
XFILLER_26_284 VDD VDD VSS VSS gf180mcu_fd_sc_mcu7t5v0__fill_2
XFILLER_118_91 VDD VDD VSS VSS gf180mcu_fd_sc_mcu7t5v0__fillcap_4
XFILLER_68_107 VDD VDD VSS VSS gf180mcu_fd_sc_mcu7t5v0__fillcap_8
XPHY_EDGE_ROW_87_Left_209 VDD VSS gf180mcu_fd_sc_mcu7t5v0__endcap
XFILLER_94_72 VDD VDD VSS VSS gf180mcu_fd_sc_mcu7t5v0__fill_1
XTAP_TAPCELL_ROW_47_533 VDD VSS gf180mcu_fd_sc_mcu7t5v0__filltie
XFILLER_17_262 VDD VDD VSS VSS gf180mcu_fd_sc_mcu7t5v0__fill_2
XFILLER_32_232 VDD VDD VSS VSS gf180mcu_fd_sc_mcu7t5v0__fillcap_8
XPHY_EDGE_ROW_96_Left_218 VDD VSS gf180mcu_fd_sc_mcu7t5v0__endcap
X_3821_ _3821_/D _4021_/CLK _3821_/Q VDD VDD VSS VSS gf180mcu_fd_sc_mcu7t5v0__dffq_1
XTAP_TAPCELL_ROW_30_433 VDD VSS gf180mcu_fd_sc_mcu7t5v0__filltie
X_3752_ _4196_/I wire91/Z _3757_/S _4151_/D VDD VDD VSS VSS gf180mcu_fd_sc_mcu7t5v0__mux2_2
X_2703_ _2760_/C _2702_/Z _3885_/D VDD VDD VSS VSS gf180mcu_fd_sc_mcu7t5v0__nor2_1
X_3683_ _3683_/A1 _3692_/A2 _3683_/B _4125_/D VDD VDD VSS VSS gf180mcu_fd_sc_mcu7t5v0__aoi21_1
X_2634_ _3240_/A1 _3892_/Q _2634_/B1 _2634_/B2 _2637_/A1 VDD VDD VSS VSS gf180mcu_fd_sc_mcu7t5v0__aoi22_1
X_2565_ _3202_/A1 _3906_/Q _3905_/Q _3200_/A1 _2567_/A2 VDD VDD VSS VSS gf180mcu_fd_sc_mcu7t5v0__aoi22_1
X_2496_ _4121_/Q _3924_/Q _2496_/B _2497_/A2 VDD VDD VSS VSS gf180mcu_fd_sc_mcu7t5v0__oai21_1
XFILLER_114_49 VDD VDD VSS VSS gf180mcu_fd_sc_mcu7t5v0__fill_1
X_4166_ _4166_/D _4166_/CLK _4166_/Q VDD VDD VSS VSS gf180mcu_fd_sc_mcu7t5v0__dffq_1
X_3117_ _3117_/A1 _3121_/A2 _3117_/B _3956_/D VDD VDD VSS VSS gf180mcu_fd_sc_mcu7t5v0__aoi21_1
X_4097_ _4097_/D clkload3/I _4097_/Q VDD VDD VSS VSS gf180mcu_fd_sc_mcu7t5v0__dffq_1
X_3048_ _3667_/C2 _2934_/Z _3241_/A2 VDD VDD VSS VSS gf180mcu_fd_sc_mcu7t5v0__nor2_1
XTAP_TAPCELL_ROW_53_569 VDD VSS gf180mcu_fd_sc_mcu7t5v0__filltie
XFILLER_23_287 VDD VDD VSS VSS gf180mcu_fd_sc_mcu7t5v0__fillcap_4
XFILLER_11_416 VDD VDD VSS VSS gf180mcu_fd_sc_mcu7t5v0__fillcap_4
XTAP_TAPCELL_ROW_44_514 VDD VSS gf180mcu_fd_sc_mcu7t5v0__filltie
XFILLER_61_305 VDD VDD VSS VSS gf180mcu_fd_sc_mcu7t5v0__fill_1
XFILLER_9_48 VDD VDD VSS VSS gf180mcu_fd_sc_mcu7t5v0__fill_2
X_2350_ _3821_/Q _2360_/A2 _2350_/B _2351_/B VDD VDD VSS VSS gf180mcu_fd_sc_mcu7t5v0__oai21_1
X_2281_ _3858_/Q _3828_/Q _2281_/Z VDD VDD VSS VSS gf180mcu_fd_sc_mcu7t5v0__xor2_1
X_4020_ _4020_/D _4021_/CLK _4020_/Q VDD VDD VSS VSS gf180mcu_fd_sc_mcu7t5v0__dffq_1
Xclkbuf_leaf_3_ext_clk_in clkload0/I _4169_/CLK VDD VDD VSS VSS gf180mcu_fd_sc_mcu7t5v0__clkbuf_8
XFILLER_20_213 VDD VDD VSS VSS gf180mcu_fd_sc_mcu7t5v0__fillcap_16
X_1996_ _3949_/Q _3102_/A1 VDD VDD VSS VSS gf180mcu_fd_sc_mcu7t5v0__clkinv_1
X_3804_ _3804_/D clkload3/I _3804_/Q VDD VDD VSS VSS gf180mcu_fd_sc_mcu7t5v0__dffq_1
X_3735_ _3750_/I1 _3746_/A2 _3746_/B _3736_/A2 VDD VDD VSS VSS gf180mcu_fd_sc_mcu7t5v0__oai21_1
Xclkbuf_0__1533_ _3537_/ZN clkbuf_0__1533_/Z VDD VDD VSS VSS gf180mcu_fd_sc_mcu7t5v0__clkbuf_16
X_3666_ _4200_/I _3748_/A1 _3726_/A1 _4142_/Q _3668_/A1 VDD VDD VSS VSS gf180mcu_fd_sc_mcu7t5v0__aoi22_1
X_3597_ _3674_/B _3597_/A2 _3629_/C2 VDD VDD VSS VSS gf180mcu_fd_sc_mcu7t5v0__nor2_1
X_2617_ _2620_/A2 _2621_/A1 _2617_/A3 _2618_/A3 VDD VDD VSS VSS gf180mcu_fd_sc_mcu7t5v0__nand3_1
X_2548_ _2548_/A1 _2548_/A2 _2548_/B1 _3878_/Q _2548_/C _3878_/D VDD VDD VSS VSS gf180mcu_fd_sc_mcu7t5v0__aoi221_1
XFILLER_114_373 VDD VDD VSS VSS gf180mcu_fd_sc_mcu7t5v0__fillcap_4
XFILLER_87_224 VDD VDD VSS VSS gf180mcu_fd_sc_mcu7t5v0__fill_1
X_2479_ _3810_/Q _2495_/A2 _2495_/B1 _3858_/Q _2495_/C _2481_/A1 VDD VDD VSS VSS gf180mcu_fd_sc_mcu7t5v0__oai221_1
XFILLER_28_313 VDD VDD VSS VSS gf180mcu_fd_sc_mcu7t5v0__fill_2
X_4149_ _4149_/D _4149_/CLK _4149_/Q VDD VDD VSS VSS gf180mcu_fd_sc_mcu7t5v0__dffq_1
XTAP_TAPCELL_ROW_66_650 VDD VSS gf180mcu_fd_sc_mcu7t5v0__filltie
XFILLER_50_33 VDD VDD VSS VSS gf180mcu_fd_sc_mcu7t5v0__fill_2
Xclkload0 clkload0/I clkload0/Z VDD VDD VSS VSS gf180mcu_fd_sc_mcu7t5v0__clkbuf_8
XFILLER_109_134 VDD VDD VSS VSS gf180mcu_fd_sc_mcu7t5v0__fill_1
XFILLER_119_2 VDD VDD VSS VSS gf180mcu_fd_sc_mcu7t5v0__fill_2
XFILLER_1_2 VDD VDD VSS VSS gf180mcu_fd_sc_mcu7t5v0__fillcap_16
XFILLER_59_31 VDD VDD VSS VSS gf180mcu_fd_sc_mcu7t5v0__fillcap_8
XFILLER_105_340 VDD VDD VSS VSS gf180mcu_fd_sc_mcu7t5v0__fillcap_4
XFILLER_120_387 VDD VDD VSS VSS gf180mcu_fd_sc_mcu7t5v0__fillcap_32
XTAP_TAPCELL_ROW_89_786 VDD VSS gf180mcu_fd_sc_mcu7t5v0__filltie
XFILLER_93_216 VDD VDD VSS VSS gf180mcu_fd_sc_mcu7t5v0__fill_2
XFILLER_46_143 VDD VDD VSS VSS gf180mcu_fd_sc_mcu7t5v0__fill_1
XFILLER_34_327 VDD VDD VSS VSS gf180mcu_fd_sc_mcu7t5v0__fill_1
XTAP_TAPCELL_ROW_72_686 VDD VSS gf180mcu_fd_sc_mcu7t5v0__filltie
X_3520_ _3520_/A1 _3520_/A2 _3526_/A2 VDD VDD VSS VSS gf180mcu_fd_sc_mcu7t5v0__nor2_1
X_3451_ _4097_/Q _3451_/A2 _4098_/Q _3453_/A2 VDD VDD VSS VSS gf180mcu_fd_sc_mcu7t5v0__aoi21_1
X_3382_ _4126_/Q _3382_/A2 _3382_/B _3383_/A4 VDD VDD VSS VSS gf180mcu_fd_sc_mcu7t5v0__oai21_1
X_2402_ _3671_/A1 _2549_/B _2402_/B _3845_/D VDD VDD VSS VSS gf180mcu_fd_sc_mcu7t5v0__oai21_1
X_2333_ _2339_/A1 _2333_/A2 _2333_/B _2335_/B VDD VDD VSS VSS gf180mcu_fd_sc_mcu7t5v0__aoi21_1
XFILLER_111_343 VDD VDD VSS VSS gf180mcu_fd_sc_mcu7t5v0__fill_1
X_2264_ _2290_/A1 _2272_/A2 _2345_/C _2290_/B1 VDD VDD VSS VSS gf180mcu_fd_sc_mcu7t5v0__aoi21_1
XFILLER_57_419 VDD VDD VSS VSS gf180mcu_fd_sc_mcu7t5v0__fill_1
X_2195_ hold191/Z _2243_/A2 _3746_/B _2196_/A2 VDD VDD VSS VSS gf180mcu_fd_sc_mcu7t5v0__oai21_1
X_4003_ _4003_/D _4170_/CLK _4003_/Q VDD VDD VSS VSS gf180mcu_fd_sc_mcu7t5v0__dffq_1
XTAP_TAPCELL_ROW_63_631 VDD VSS gf180mcu_fd_sc_mcu7t5v0__filltie
XFILLER_52_168 VDD VDD VSS VSS gf180mcu_fd_sc_mcu7t5v0__fillcap_4
X_1979_ _3966_/Q _3138_/A1 VDD VDD VSS VSS gf180mcu_fd_sc_mcu7t5v0__clkinv_1
XFILLER_106_104 VDD VDD VSS VSS gf180mcu_fd_sc_mcu7t5v0__fill_1
X_3718_ _4139_/Q _3699_/Z wire81/Z _3719_/A2 VDD VDD VSS VSS gf180mcu_fd_sc_mcu7t5v0__oai21_1
XFILLER_20_58 VDD VDD VSS VSS gf180mcu_fd_sc_mcu7t5v0__fill_2
X_3649_ _3649_/A1 _3649_/A2 _3649_/A3 _3650_/B2 VDD VDD VSS VSS gf180mcu_fd_sc_mcu7t5v0__nand3_1
XFILLER_20_69 VDD VDD VSS VSS gf180mcu_fd_sc_mcu7t5v0__fillcap_16
XFILLER_96_29 VDD VDD VSS VSS gf180mcu_fd_sc_mcu7t5v0__fill_1
XFILLER_75_216 VDD VDD VSS VSS gf180mcu_fd_sc_mcu7t5v0__fill_1
XFILLER_102_387 VDD VDD VSS VSS gf180mcu_fd_sc_mcu7t5v0__fill_2
XFILLER_16_305 VDD VDD VSS VSS gf180mcu_fd_sc_mcu7t5v0__fillcap_4
XTAP_TAPCELL_ROW_86_767 VDD VSS gf180mcu_fd_sc_mcu7t5v0__filltie
XFILLER_71_422 VDD VDD VSS VSS gf180mcu_fd_sc_mcu7t5v0__fillcap_4
XFILLER_43_146 VDD VDD VSS VSS gf180mcu_fd_sc_mcu7t5v0__fill_2
XTAP_TAPCELL_ROW_106_890 VDD VSS gf180mcu_fd_sc_mcu7t5v0__filltie
XFILLER_101_72 VDD VDD VSS VSS gf180mcu_fd_sc_mcu7t5v0__fillcap_4
XFILLER_61_54 VDD VDD VSS VSS gf180mcu_fd_sc_mcu7t5v0__fillcap_16
XFILLER_61_76 VDD VDD VSS VSS gf180mcu_fd_sc_mcu7t5v0__fill_1
XFILLER_112_107 VDD VDD VSS VSS gf180mcu_fd_sc_mcu7t5v0__fill_1
XTAP_TAPCELL_ROW_77_712 VDD VSS gf180mcu_fd_sc_mcu7t5v0__filltie
XFILLER_34_102 VDD VDD VSS VSS gf180mcu_fd_sc_mcu7t5v0__fill_2
XFILLER_74_282 VDD VDD VSS VSS gf180mcu_fd_sc_mcu7t5v0__fillcap_4
XTAP_TAPCELL_ROW_17_355 VDD VSS gf180mcu_fd_sc_mcu7t5v0__filltie
X_2951_ _3022_/A3 _3720_/A2 _3060_/A1 VDD VDD VSS VSS gf180mcu_fd_sc_mcu7t5v0__nor2_1
XTAP_TAPCELL_ROW_60_612 VDD VSS gf180mcu_fd_sc_mcu7t5v0__filltie
XFILLER_96_4 VDD VDD VSS VSS gf180mcu_fd_sc_mcu7t5v0__fill_1
X_1902_ _4070_/Q _3377_/A2 VDD VDD VSS VSS gf180mcu_fd_sc_mcu7t5v0__clkinv_1
X_2882_ _2884_/A1 _2881_/Z _2885_/A2 VDD VDD VSS VSS gf180mcu_fd_sc_mcu7t5v0__nand2_1
X_3503_ _3503_/A1 _3503_/A2 _4089_/D VDD VDD VSS VSS gf180mcu_fd_sc_mcu7t5v0__nor2_1
X_3434_ _4077_/Q _3430_/Z _3439_/B _3435_/A2 VDD VDD VSS VSS gf180mcu_fd_sc_mcu7t5v0__oai21_1
XFILLER_103_107 VDD VDD VSS VSS gf180mcu_fd_sc_mcu7t5v0__fillcap_8
X_3365_ _3365_/I _4061_/D VDD VDD VSS VSS gf180mcu_fd_sc_mcu7t5v0__clkinv_1
X_2316_ _3825_/Q _2311_/B _2331_/A2 _2317_/A4 VDD VDD VSS VSS gf180mcu_fd_sc_mcu7t5v0__nor3_1
X_3296_ _3398_/A3 _4039_/Q _3297_/A3 VDD VDD VSS VSS gf180mcu_fd_sc_mcu7t5v0__nor2_1
X_2247_ _2247_/A1 _2247_/A2 _3804_/D VDD VDD VSS VSS gf180mcu_fd_sc_mcu7t5v0__nor2_1
XFILLER_72_219 VDD VDD VSS VSS gf180mcu_fd_sc_mcu7t5v0__fill_1
XTAP_TAPCELL_ROW_0_245 VDD VSS gf180mcu_fd_sc_mcu7t5v0__filltie
XFILLER_53_422 VDD VDD VSS VSS gf180mcu_fd_sc_mcu7t5v0__fillcap_4
XFILLER_65_282 VDD VDD VSS VSS gf180mcu_fd_sc_mcu7t5v0__fill_1
X_2178_ _2178_/A1 _2178_/A2 hold176/I VDD VDD VSS VSS gf180mcu_fd_sc_mcu7t5v0__nor2_1
XTAP_TAPCELL_ROW_83_748 VDD VSS gf180mcu_fd_sc_mcu7t5v0__filltie
XFILLER_15_69 VDD VDD VSS VSS gf180mcu_fd_sc_mcu7t5v0__fill_1
XFILLER_80_296 VDD VDD VSS VSS gf180mcu_fd_sc_mcu7t5v0__fillcap_8
XTAP_TAPCELL_ROW_103_871 VDD VSS gf180mcu_fd_sc_mcu7t5v0__filltie
XFILLER_31_68 VDD VDD VSS VSS gf180mcu_fd_sc_mcu7t5v0__fill_2
XTAP_TAPCELL_ROW_8_301 VDD VSS gf180mcu_fd_sc_mcu7t5v0__filltie
Xoutput24 _2078_/ZN i2c_sda_out_pin_ctrl_n VDD VDD VSS VSS gf180mcu_fd_sc_mcu7t5v0__dlyb_1
Xoutput13 _3933_/Q PAD_OE[1] VDD VDD VSS VSS gf180mcu_fd_sc_mcu7t5v0__dlyb_1
XFILLER_102_162 VDD VDD VSS VSS gf180mcu_fd_sc_mcu7t5v0__fill_1
XFILLER_16_113 VDD VDD VSS VSS gf180mcu_fd_sc_mcu7t5v0__fillcap_4
XFILLER_56_282 VDD VDD VSS VSS gf180mcu_fd_sc_mcu7t5v0__fill_1
XPHY_EDGE_ROW_19_Right_19 VDD VSS gf180mcu_fd_sc_mcu7t5v0__endcap
XTAP_TAPCELL_ROW_14_336 VDD VSS gf180mcu_fd_sc_mcu7t5v0__filltie
XPHY_EDGE_ROW_28_Right_28 VDD VSS gf180mcu_fd_sc_mcu7t5v0__endcap
XTAP_TAPCELL_ROW_109_908 VDD VSS gf180mcu_fd_sc_mcu7t5v0__filltie
X_3150_ _3286_/A1 _3151_/A2 wire81/Z _3151_/B VDD VDD VSS VSS gf180mcu_fd_sc_mcu7t5v0__oai21_1
XFILLER_97_94 VDD VDD VSS VSS gf180mcu_fd_sc_mcu7t5v0__fill_2
X_2101_ wire79/Z _2938_/A3 _3592_/A1 VDD VDD VSS VSS gf180mcu_fd_sc_mcu7t5v0__nand2_1
X_3081_ wire94/Z _3082_/A2 wire81/Z _3082_/B VDD VDD VSS VSS gf180mcu_fd_sc_mcu7t5v0__oai21_1
X_2032_ _3817_/Q _2505_/A2 VDD VDD VSS VSS gf180mcu_fd_sc_mcu7t5v0__clkinv_1
XTAP_TAPCELL_ROW_117_952 VDD VSS gf180mcu_fd_sc_mcu7t5v0__filltie
XFILLER_35_411 VDD VDD VSS VSS gf180mcu_fd_sc_mcu7t5v0__fillcap_8
XFILLER_35_422 VDD VDD VSS VSS gf180mcu_fd_sc_mcu7t5v0__fillcap_4
XPHY_EDGE_ROW_37_Right_37 VDD VSS gf180mcu_fd_sc_mcu7t5v0__endcap
XFILLER_47_282 VDD VDD VSS VSS gf180mcu_fd_sc_mcu7t5v0__fill_2
XFILLER_62_274 VDD VDD VSS VSS gf180mcu_fd_sc_mcu7t5v0__fill_1
X_3983_ _3983_/D clkload2/I _3983_/Q VDD VDD VSS VSS gf180mcu_fd_sc_mcu7t5v0__dffq_1
X_2934_ _3928_/Q _3927_/Q _3671_/A1 _2934_/Z VDD VDD VSS VSS gf180mcu_fd_sc_mcu7t5v0__or3_1
X_2865_ _2819_/Z _2865_/A2 _2865_/A3 _2862_/I _2865_/Z VDD VDD VSS VSS gf180mcu_fd_sc_mcu7t5v0__or4_1
XFILLER_30_160 VDD VDD VSS VSS gf180mcu_fd_sc_mcu7t5v0__fill_2
XTAP_TAPCELL_ROW_100_852 VDD VSS gf180mcu_fd_sc_mcu7t5v0__filltie
XPHY_EDGE_ROW_46_Right_46 VDD VSS gf180mcu_fd_sc_mcu7t5v0__endcap
X_2796_ _2802_/A4 _2796_/A2 _2797_/A2 VDD VDD VSS VSS gf180mcu_fd_sc_mcu7t5v0__xnor2_1
XPHY_EDGE_ROW_107_Left_229 VDD VSS gf180mcu_fd_sc_mcu7t5v0__endcap
Xtop_level_100 trig_out_cs_control VDD VDD VSS VSS gf180mcu_fd_sc_mcu7t5v0__tiel
Xtop_level_111 i2c_sda_out_pdrv_control[1] VDD VDD VSS VSS gf180mcu_fd_sc_mcu7t5v0__tieh
XFILLER_89_127 VDD VDD VSS VSS gf180mcu_fd_sc_mcu7t5v0__fillcap_4
XFILLER_104_416 VDD VDD VSS VSS gf180mcu_fd_sc_mcu7t5v0__fillcap_8
X_3417_ _4071_/Q _3414_/Z _3419_/A2 VDD VDD VSS VSS gf180mcu_fd_sc_mcu7t5v0__nor2_1
X_3348_ _4056_/Q _3345_/Z _3348_/B _3349_/I VDD VDD VSS VSS gf180mcu_fd_sc_mcu7t5v0__oai21_1
XFILLER_85_322 VDD VDD VSS VSS gf180mcu_fd_sc_mcu7t5v0__fill_2
XPHY_EDGE_ROW_116_Left_238 VDD VSS gf180mcu_fd_sc_mcu7t5v0__endcap
XPHY_EDGE_ROW_55_Right_55 VDD VSS gf180mcu_fd_sc_mcu7t5v0__endcap
X_3279_ _3279_/A1 _3283_/A2 _3279_/B _4032_/D VDD VDD VSS VSS gf180mcu_fd_sc_mcu7t5v0__aoi21_1
XFILLER_21_171 VDD VDD VSS VSS gf180mcu_fd_sc_mcu7t5v0__fillcap_16
XTAP_TAPCELL_ROW_11_317 VDD VSS gf180mcu_fd_sc_mcu7t5v0__filltie
XPHY_EDGE_ROW_64_Right_64 VDD VSS gf180mcu_fd_sc_mcu7t5v0__endcap
XFILLER_107_232 VDD VDD VSS VSS gf180mcu_fd_sc_mcu7t5v0__fill_1
XFILLER_107_254 VDD VDD VSS VSS gf180mcu_fd_sc_mcu7t5v0__fill_1
XFILLER_107_265 VDD VDD VSS VSS gf180mcu_fd_sc_mcu7t5v0__fill_2
XFILLER_67_31 VDD VDD VSS VSS gf180mcu_fd_sc_mcu7t5v0__fillcap_4
XFILLER_95_119 VDD VDD VSS VSS gf180mcu_fd_sc_mcu7t5v0__fillcap_8
XFILLER_107_82 VDD VDD VSS VSS gf180mcu_fd_sc_mcu7t5v0__fillcap_4
XPHY_EDGE_ROW_73_Right_73 VDD VSS gf180mcu_fd_sc_mcu7t5v0__endcap
XFILLER_88_193 VDD VDD VSS VSS gf180mcu_fd_sc_mcu7t5v0__fill_2
XFILLER_17_422 VDD VDD VSS VSS gf180mcu_fd_sc_mcu7t5v0__fillcap_4
XFILLER_29_260 VDD VDD VSS VSS gf180mcu_fd_sc_mcu7t5v0__fillcap_8
XFILLER_29_282 VDD VDD VSS VSS gf180mcu_fd_sc_mcu7t5v0__fill_2
XFILLER_91_325 VDD VDD VSS VSS gf180mcu_fd_sc_mcu7t5v0__fill_2
XFILLER_91_358 VDD VDD VSS VSS gf180mcu_fd_sc_mcu7t5v0__fillcap_4
XFILLER_32_425 VDD VDD VSS VSS gf180mcu_fd_sc_mcu7t5v0__fill_1
XPHY_EDGE_ROW_82_Right_82 VDD VSS gf180mcu_fd_sc_mcu7t5v0__endcap
XFILLER_12_182 VDD VDD VSS VSS gf180mcu_fd_sc_mcu7t5v0__fillcap_4
X_2650_ _4038_/Q _2915_/A2 _2697_/A2 VDD VDD VSS VSS gf180mcu_fd_sc_mcu7t5v0__nand2_1
XFILLER_8_186 VDD VDD VSS VSS gf180mcu_fd_sc_mcu7t5v0__fill_2
X_2581_ _3986_/Q _2768_/A2 _2776_/A2 _3985_/Q _2582_/C VDD VDD VSS VSS gf180mcu_fd_sc_mcu7t5v0__aoi22_1
XFILLER_4_381 VDD VDD VSS VSS gf180mcu_fd_sc_mcu7t5v0__fillcap_4
X_3202_ _3202_/A1 _3206_/A2 _3202_/B _3996_/D VDD VDD VSS VSS gf180mcu_fd_sc_mcu7t5v0__aoi21_1
XFILLER_79_160 VDD VDD VSS VSS gf180mcu_fd_sc_mcu7t5v0__fillcap_4
XPHY_EDGE_ROW_91_Right_91 VDD VSS gf180mcu_fd_sc_mcu7t5v0__endcap
XFILLER_101_419 VDD VDD VSS VSS gf180mcu_fd_sc_mcu7t5v0__fill_1
XFILLER_67_366 VDD VDD VSS VSS gf180mcu_fd_sc_mcu7t5v0__fillcap_4
X_3133_ _3754_/I1 _3138_/A2 wire81/Z _3134_/B VDD VDD VSS VSS gf180mcu_fd_sc_mcu7t5v0__oai21_1
XTAP_TAPCELL_ROW_93_810 VDD VSS gf180mcu_fd_sc_mcu7t5v0__filltie
XFILLER_103_18 VDD VDD VSS VSS gf180mcu_fd_sc_mcu7t5v0__fillcap_4
X_3064_ _3064_/A1 _3080_/A2 _3064_/B _3931_/D VDD VDD VSS VSS gf180mcu_fd_sc_mcu7t5v0__aoi21_1
X_2015_ _2015_/I _3062_/A1 VDD VDD VSS VSS gf180mcu_fd_sc_mcu7t5v0__clkinv_1
XFILLER_50_233 VDD VDD VSS VSS gf180mcu_fd_sc_mcu7t5v0__fill_2
XTAP_TAPCELL_ROW_33_453 VDD VSS gf180mcu_fd_sc_mcu7t5v0__filltie
X_3966_ _3966_/D _4034_/CLK _3966_/Q VDD VDD VSS VSS gf180mcu_fd_sc_mcu7t5v0__dffq_1
X_2917_ _2923_/A3 _2924_/A1 _2919_/B VDD VDD VSS VSS gf180mcu_fd_sc_mcu7t5v0__nand2_1
X_3897_ _3897_/D clkload9/I _3897_/Q VDD VDD VSS VSS gf180mcu_fd_sc_mcu7t5v0__dffq_1
X_2848_ _3965_/Q _3907_/Q _2848_/Z VDD VDD VSS VSS gf180mcu_fd_sc_mcu7t5v0__xor2_1
X_2779_ _2771_/B _2805_/A2 _2779_/B _2779_/C _2784_/B VDD VDD VSS VSS gf180mcu_fd_sc_mcu7t5v0__oai211_1
Xhold131 _3880_/Q hold131/Z VDD VDD VSS VSS gf180mcu_fd_sc_mcu7t5v0__dlyc_1
Xhold120 _4160_/Q _4161_/D VDD VDD VSS VSS gf180mcu_fd_sc_mcu7t5v0__dlyc_1
Xhold142 _3923_/Q hold142/Z VDD VDD VSS VSS gf180mcu_fd_sc_mcu7t5v0__dlyc_1
Xhold153 _3919_/Q hold153/Z VDD VDD VSS VSS gf180mcu_fd_sc_mcu7t5v0__dlyc_1
Xhold164 hold164/I _3802_/D VDD VDD VSS VSS gf180mcu_fd_sc_mcu7t5v0__dlyc_1
Xhold186 _3795_/Q hold186/Z VDD VDD VSS VSS gf180mcu_fd_sc_mcu7t5v0__dlyc_1
Xhold175 _4060_/Q hold175/Z VDD VDD VSS VSS gf180mcu_fd_sc_mcu7t5v0__dlyc_1
Xhold197 hold197/I _3776_/D VDD VDD VSS VSS gf180mcu_fd_sc_mcu7t5v0__dlyc_1
XFILLER_104_268 VDD VDD VSS VSS gf180mcu_fd_sc_mcu7t5v0__fill_2
XFILLER_73_314 VDD VDD VSS VSS gf180mcu_fd_sc_mcu7t5v0__fill_2
XFILLER_85_174 VDD VDD VSS VSS gf180mcu_fd_sc_mcu7t5v0__fillcap_4
XFILLER_26_230 VDD VDD VSS VSS gf180mcu_fd_sc_mcu7t5v0__fill_1
XTAP_TAPCELL_ROW_56_589 VDD VSS gf180mcu_fd_sc_mcu7t5v0__filltie
XFILLER_14_425 VDD VDD VSS VSS gf180mcu_fd_sc_mcu7t5v0__fill_1
XFILLER_41_222 VDD VDD VSS VSS gf180mcu_fd_sc_mcu7t5v0__fill_1
XFILLER_110_205 VDD VDD VSS VSS gf180mcu_fd_sc_mcu7t5v0__fill_1
XFILLER_68_119 VDD VDD VSS VSS gf180mcu_fd_sc_mcu7t5v0__fill_2
XFILLER_78_52 VDD VDD VSS VSS gf180mcu_fd_sc_mcu7t5v0__fillcap_4
XFILLER_103_290 VDD VDD VSS VSS gf180mcu_fd_sc_mcu7t5v0__fillcap_16
XFILLER_76_163 VDD VDD VSS VSS gf180mcu_fd_sc_mcu7t5v0__fillcap_8
XTAP_TAPCELL_ROW_47_534 VDD VSS gf180mcu_fd_sc_mcu7t5v0__filltie
XFILLER_91_133 VDD VDD VSS VSS gf180mcu_fd_sc_mcu7t5v0__fillcap_4
X_3820_ _3820_/D clkload8/I _3820_/Q VDD VDD VSS VSS gf180mcu_fd_sc_mcu7t5v0__dffq_1
XFILLER_32_244 VDD VDD VSS VSS gf180mcu_fd_sc_mcu7t5v0__fill_1
X_3751_ _4195_/I _3751_/I1 _3757_/S _4150_/D VDD VDD VSS VSS gf180mcu_fd_sc_mcu7t5v0__mux2_2
XTAP_TAPCELL_ROW_30_434 VDD VSS gf180mcu_fd_sc_mcu7t5v0__filltie
X_2702_ _3090_/A1 _3885_/Q _2702_/Z VDD VDD VSS VSS gf180mcu_fd_sc_mcu7t5v0__xor2_1
X_3682_ _3750_/I1 _3692_/A2 _3746_/B _3683_/B VDD VDD VSS VSS gf180mcu_fd_sc_mcu7t5v0__oai21_1
X_2633_ _4013_/Q _2746_/A2 _2633_/B1 _2633_/B2 _2633_/C1 _4012_/Q _2634_/B2 VDD VDD
+ VSS VSS gf180mcu_fd_sc_mcu7t5v0__oai222_1
X_2564_ _3998_/Q _2856_/A2 _2847_/A2 _3997_/Q _2568_/B VDD VDD VSS VSS gf180mcu_fd_sc_mcu7t5v0__oai22_1
XFILLER_99_222 VDD VDD VSS VSS gf180mcu_fd_sc_mcu7t5v0__fill_1
X_2495_ _3814_/Q _2495_/A2 _2495_/B1 _3862_/Q _2495_/C _2497_/A1 VDD VDD VSS VSS gf180mcu_fd_sc_mcu7t5v0__oai221_1
XFILLER_99_255 VDD VDD VSS VSS gf180mcu_fd_sc_mcu7t5v0__fill_2
XFILLER_99_266 VDD VDD VSS VSS gf180mcu_fd_sc_mcu7t5v0__fill_1
XFILLER_99_277 VDD VDD VSS VSS gf180mcu_fd_sc_mcu7t5v0__fill_2
XFILLER_101_205 VDD VDD VSS VSS gf180mcu_fd_sc_mcu7t5v0__fillcap_4
XFILLER_101_238 VDD VDD VSS VSS gf180mcu_fd_sc_mcu7t5v0__fillcap_4
XFILLER_67_130 VDD VDD VSS VSS gf180mcu_fd_sc_mcu7t5v0__fillcap_8
X_4165_ _4165_/D _4169_/CLK _4165_/Q VDD VDD VSS VSS gf180mcu_fd_sc_mcu7t5v0__dffq_1
X_3116_ _3852_/Q _3121_/A2 _3256_/B _3117_/B VDD VDD VSS VSS gf180mcu_fd_sc_mcu7t5v0__oai21_1
X_4096_ _4096_/D clkload3/I _4096_/Q VDD VDD VSS VSS gf180mcu_fd_sc_mcu7t5v0__dffq_1
X_3047_ _3731_/C _3047_/A2 _3926_/D VDD VDD VSS VSS gf180mcu_fd_sc_mcu7t5v0__nor2_1
XFILLER_70_306 VDD VDD VSS VSS gf180mcu_fd_sc_mcu7t5v0__fill_2
XFILLER_70_317 VDD VDD VSS VSS gf180mcu_fd_sc_mcu7t5v0__fill_2
XFILLER_23_222 VDD VDD VSS VSS gf180mcu_fd_sc_mcu7t5v0__fillcap_8
X_3949_ _3949_/D clkload9/I _3949_/Q VDD VDD VSS VSS gf180mcu_fd_sc_mcu7t5v0__dffq_1
XFILLER_109_349 VDD VDD VSS VSS gf180mcu_fd_sc_mcu7t5v0__fill_1
XFILLER_2_115 VDD VDD VSS VSS gf180mcu_fd_sc_mcu7t5v0__fill_1
XFILLER_48_66 VDD VDD VSS VSS gf180mcu_fd_sc_mcu7t5v0__fill_1
XFILLER_58_141 VDD VDD VSS VSS gf180mcu_fd_sc_mcu7t5v0__fillcap_16
XFILLER_100_271 VDD VDD VSS VSS gf180mcu_fd_sc_mcu7t5v0__fill_1
XFILLER_73_111 VDD VDD VSS VSS gf180mcu_fd_sc_mcu7t5v0__fill_1
XFILLER_73_133 VDD VDD VSS VSS gf180mcu_fd_sc_mcu7t5v0__fillcap_4
XTAP_TAPCELL_ROW_44_515 VDD VSS gf180mcu_fd_sc_mcu7t5v0__filltie
XFILLER_73_188 VDD VDD VSS VSS gf180mcu_fd_sc_mcu7t5v0__fillcap_4
XFILLER_9_16 VDD VDD VSS VSS gf180mcu_fd_sc_mcu7t5v0__fill_1
XFILLER_80_31 VDD VDD VSS VSS gf180mcu_fd_sc_mcu7t5v0__fillcap_4
XPHY_EDGE_ROW_108_Right_108 VDD VSS gf180mcu_fd_sc_mcu7t5v0__endcap
XFILLER_108_393 VDD VDD VSS VSS gf180mcu_fd_sc_mcu7t5v0__fillcap_32
X_2280_ _3862_/Q _3832_/Q _2280_/Z VDD VDD VSS VSS gf180mcu_fd_sc_mcu7t5v0__xor2_1
XFILLER_96_247 VDD VDD VSS VSS gf180mcu_fd_sc_mcu7t5v0__fillcap_4
XFILLER_49_163 VDD VDD VSS VSS gf180mcu_fd_sc_mcu7t5v0__fillcap_4
XFILLER_64_100 VDD VDD VSS VSS gf180mcu_fd_sc_mcu7t5v0__fillcap_4
XFILLER_52_317 VDD VDD VSS VSS gf180mcu_fd_sc_mcu7t5v0__fill_2
XFILLER_64_155 VDD VDD VSS VSS gf180mcu_fd_sc_mcu7t5v0__fillcap_4
XFILLER_64_177 VDD VDD VSS VSS gf180mcu_fd_sc_mcu7t5v0__fillcap_4
X_3803_ _3803_/D _4104_/CLK _3803_/Q VDD VDD VSS VSS gf180mcu_fd_sc_mcu7t5v0__dffq_1
X_1995_ _3950_/Q _3104_/A1 VDD VDD VSS VSS gf180mcu_fd_sc_mcu7t5v0__clkinv_1
X_3734_ hold135/Z _3725_/Z _3736_/A1 VDD VDD VSS VSS gf180mcu_fd_sc_mcu7t5v0__nor2_1
Xclkbuf_0__1532_ _3536_/ZN clkbuf_0__1532_/Z VDD VDD VSS VSS gf180mcu_fd_sc_mcu7t5v0__clkbuf_16
X_3665_ _3665_/A1 _3665_/A2 _3665_/A3 _3667_/C1 VDD VDD VSS VSS gf180mcu_fd_sc_mcu7t5v0__nand3_1
X_2616_ _3999_/Q _2669_/A2 _2621_/B _2616_/C _2617_/A3 VDD VDD VSS VSS gf180mcu_fd_sc_mcu7t5v0__aoi211_1
XFILLER_106_319 VDD VDD VSS VSS gf180mcu_fd_sc_mcu7t5v0__fill_1
X_3596_ _3596_/A1 _3596_/A2 _3596_/A3 _3602_/A2 VDD VDD VSS VSS gf180mcu_fd_sc_mcu7t5v0__nand3_1
X_2547_ _3878_/Q _2547_/A2 _2548_/C VDD VDD VSS VSS gf180mcu_fd_sc_mcu7t5v0__nor2_1
X_2478_ _2478_/I0 hold185/Z _2482_/S _3865_/D VDD VDD VSS VSS gf180mcu_fd_sc_mcu7t5v0__mux2_2
XFILLER_75_409 VDD VDD VSS VSS gf180mcu_fd_sc_mcu7t5v0__fill_2
X_4148_ _4148_/D _4155_/CLK _4148_/Q VDD VDD VSS VSS gf180mcu_fd_sc_mcu7t5v0__dffq_1
X_4079_ _4079_/D _4079_/CLK _4079_/Q VDD VDD VSS VSS gf180mcu_fd_sc_mcu7t5v0__dffq_1
XTAP_TAPCELL_ROW_66_651 VDD VSS gf180mcu_fd_sc_mcu7t5v0__filltie
XFILLER_70_136 VDD VDD VSS VSS gf180mcu_fd_sc_mcu7t5v0__fillcap_4
XFILLER_11_269 VDD VDD VSS VSS gf180mcu_fd_sc_mcu7t5v0__fill_2
XFILLER_7_207 VDD VDD VSS VSS gf180mcu_fd_sc_mcu7t5v0__fill_2
Xclkload1 clkload1/I clkload1/ZN VDD VDD VSS VSS gf180mcu_fd_sc_mcu7t5v0__inv_3
XFILLER_109_146 VDD VDD VSS VSS gf180mcu_fd_sc_mcu7t5v0__fillcap_4
XFILLER_120_311 VDD VDD VSS VSS gf180mcu_fd_sc_mcu7t5v0__fillcap_4
XFILLER_105_385 VDD VDD VSS VSS gf180mcu_fd_sc_mcu7t5v0__fillcap_4
XFILLER_78_269 VDD VDD VSS VSS gf180mcu_fd_sc_mcu7t5v0__fill_1
XTAP_TAPCELL_ROW_89_787 VDD VSS gf180mcu_fd_sc_mcu7t5v0__filltie
XFILLER_75_31 VDD VDD VSS VSS gf180mcu_fd_sc_mcu7t5v0__fill_1
XFILLER_19_358 VDD VDD VSS VSS gf180mcu_fd_sc_mcu7t5v0__fillcap_32
XFILLER_34_306 VDD VDD VSS VSS gf180mcu_fd_sc_mcu7t5v0__fill_1
XFILLER_46_177 VDD VDD VSS VSS gf180mcu_fd_sc_mcu7t5v0__fillcap_4
XTAP_TAPCELL_ROW_72_687 VDD VSS gf180mcu_fd_sc_mcu7t5v0__filltie
X_3450_ _3450_/A1 _3450_/A2 _3450_/B _3451_/A2 VDD VDD VSS VSS gf180mcu_fd_sc_mcu7t5v0__oai21_1
X_2401_ _2401_/I _3844_/D VDD VDD VSS VSS gf180mcu_fd_sc_mcu7t5v0__clkinv_1
X_3381_ _3709_/A1 _4075_/Q _4073_/Q _3705_/A1 _3382_/A2 _4126_/Q _3382_/B VDD VDD
+ VSS VSS gf180mcu_fd_sc_mcu7t5v0__aoi222_1
X_2332_ _2360_/A2 _2332_/A2 _2333_/A2 VDD VDD VSS VSS gf180mcu_fd_sc_mcu7t5v0__nand2_1
XFILLER_69_214 VDD VDD VSS VSS gf180mcu_fd_sc_mcu7t5v0__fill_1
X_2263_ _2377_/A1 _2260_/Z _2345_/B _2272_/A2 VDD VDD VSS VSS gf180mcu_fd_sc_mcu7t5v0__aoi21_1
X_4002_ _4002_/D _4170_/CLK _4002_/Q VDD VDD VSS VSS gf180mcu_fd_sc_mcu7t5v0__dffq_1
X_2194_ _4083_/Q _2242_/A2 _2196_/A1 VDD VDD VSS VSS gf180mcu_fd_sc_mcu7t5v0__nor2_1
XFILLER_1_72 VDD VDD VSS VSS gf180mcu_fd_sc_mcu7t5v0__fill_2
XTAP_TAPCELL_ROW_63_632 VDD VSS gf180mcu_fd_sc_mcu7t5v0__filltie
XFILLER_119_422 VDD VDD VSS VSS gf180mcu_fd_sc_mcu7t5v0__fillcap_4
X_1978_ _3967_/Q _3141_/A1 VDD VDD VSS VSS gf180mcu_fd_sc_mcu7t5v0__clkinv_1
X_3717_ _3854_/Q _3717_/A2 _3719_/A1 VDD VDD VSS VSS gf180mcu_fd_sc_mcu7t5v0__nor2_1
X_3648_ _4137_/Q _3667_/A2 _3726_/A1 _4147_/Q _3649_/A3 VDD VDD VSS VSS gf180mcu_fd_sc_mcu7t5v0__aoi22_1
X_3579_ _4112_/Q _3578_/B _3579_/B _3580_/B VDD VDD VSS VSS gf180mcu_fd_sc_mcu7t5v0__aoi21_1
XFILLER_114_171 VDD VDD VSS VSS gf180mcu_fd_sc_mcu7t5v0__fillcap_4
XFILLER_114_193 VDD VDD VSS VSS gf180mcu_fd_sc_mcu7t5v0__fill_2
XFILLER_102_366 VDD VDD VSS VSS gf180mcu_fd_sc_mcu7t5v0__fill_1
XFILLER_56_420 VDD VDD VSS VSS gf180mcu_fd_sc_mcu7t5v0__fillcap_4
XFILLER_68_280 VDD VDD VSS VSS gf180mcu_fd_sc_mcu7t5v0__fillcap_4
XFILLER_28_155 VDD VDD VSS VSS gf180mcu_fd_sc_mcu7t5v0__fillcap_8
XTAP_TAPCELL_ROW_86_768 VDD VSS gf180mcu_fd_sc_mcu7t5v0__filltie
XFILLER_28_177 VDD VDD VSS VSS gf180mcu_fd_sc_mcu7t5v0__fill_2
XFILLER_16_317 VDD VDD VSS VSS gf180mcu_fd_sc_mcu7t5v0__fillcap_64
XFILLER_45_45 VDD VDD VSS VSS gf180mcu_fd_sc_mcu7t5v0__fillcap_8
XFILLER_71_401 VDD VDD VSS VSS gf180mcu_fd_sc_mcu7t5v0__fill_1
XTAP_TAPCELL_ROW_106_891 VDD VSS gf180mcu_fd_sc_mcu7t5v0__filltie
XFILLER_61_44 VDD VDD VSS VSS gf180mcu_fd_sc_mcu7t5v0__fill_1
XFILLER_61_88 VDD VDD VSS VSS gf180mcu_fd_sc_mcu7t5v0__fillcap_4
XFILLER_120_152 VDD VDD VSS VSS gf180mcu_fd_sc_mcu7t5v0__fillcap_16
XTAP_TAPCELL_ROW_77_713 VDD VSS gf180mcu_fd_sc_mcu7t5v0__filltie
XFILLER_120_174 VDD VDD VSS VSS gf180mcu_fd_sc_mcu7t5v0__fill_1
XFILLER_19_100 VDD VDD VSS VSS gf180mcu_fd_sc_mcu7t5v0__fill_2
XFILLER_19_90 VDD VDD VSS VSS gf180mcu_fd_sc_mcu7t5v0__fill_2
XFILLER_81_209 VDD VDD VSS VSS gf180mcu_fd_sc_mcu7t5v0__fill_1
XFILLER_19_166 VDD VDD VSS VSS gf180mcu_fd_sc_mcu7t5v0__fill_2
XFILLER_34_136 VDD VDD VSS VSS gf180mcu_fd_sc_mcu7t5v0__fillcap_16
XTAP_TAPCELL_ROW_17_356 VDD VSS gf180mcu_fd_sc_mcu7t5v0__filltie
X_2950_ _2954_/A1 _2943_/Z _3014_/A2 VDD VDD VSS VSS gf180mcu_fd_sc_mcu7t5v0__nor2_1
XTAP_TAPCELL_ROW_60_613 VDD VSS gf180mcu_fd_sc_mcu7t5v0__filltie
X_2881_ _2881_/A1 _2883_/A3 _2881_/Z VDD VDD VSS VSS gf180mcu_fd_sc_mcu7t5v0__and2_1
X_1901_ _4072_/Q _3392_/A1 VDD VDD VSS VSS gf180mcu_fd_sc_mcu7t5v0__clkinv_1
Xclkbuf_0_signal_input_regs clkbuf_regs_0_signal_clock/Z clkbuf_0_signal_input_regs/Z
+ VDD VDD VSS VSS gf180mcu_fd_sc_mcu7t5v0__clkbuf_16
XFILLER_116_425 VDD VDD VSS VSS gf180mcu_fd_sc_mcu7t5v0__fill_1
X_3502_ _4089_/Q _3496_/Z _3538_/B _3503_/A2 VDD VDD VSS VSS gf180mcu_fd_sc_mcu7t5v0__oai21_1
X_3433_ _4077_/Q _3430_/Z _3433_/Z VDD VDD VSS VSS gf180mcu_fd_sc_mcu7t5v0__and2_1
Xclkbuf_1_1__f_ext_clk_in clkbuf_0_ext_clk_in/Z clkload0/I VDD VDD VSS VSS gf180mcu_fd_sc_mcu7t5v0__clkbuf_16
XFILLER_103_119 VDD VDD VSS VSS gf180mcu_fd_sc_mcu7t5v0__fill_1
XFILLER_111_130 VDD VDD VSS VSS gf180mcu_fd_sc_mcu7t5v0__fillcap_8
X_3364_ _4061_/Q _3360_/Z _3364_/B _3365_/I VDD VDD VSS VSS gf180mcu_fd_sc_mcu7t5v0__oai21_1
X_2315_ _4158_/Q _2252_/Z _2331_/A2 VDD VDD VSS VSS gf180mcu_fd_sc_mcu7t5v0__nand2_1
XPHY_EDGE_ROW_29_Left_151 VDD VSS gf180mcu_fd_sc_mcu7t5v0__endcap
X_3295_ _3398_/A3 _4039_/Q _3295_/Z VDD VDD VSS VSS gf180mcu_fd_sc_mcu7t5v0__and2_1
X_2246_ hold207/Z _2111_/Z _3746_/B _2247_/A2 VDD VDD VSS VSS gf180mcu_fd_sc_mcu7t5v0__oai21_1
XFILLER_57_228 VDD VDD VSS VSS gf180mcu_fd_sc_mcu7t5v0__fill_2
XFILLER_72_209 VDD VDD VSS VSS gf180mcu_fd_sc_mcu7t5v0__fillcap_8
X_2177_ _3779_/Q _2243_/A2 _3746_/B _2178_/A2 VDD VDD VSS VSS gf180mcu_fd_sc_mcu7t5v0__oai21_1
XTAP_TAPCELL_ROW_83_749 VDD VSS gf180mcu_fd_sc_mcu7t5v0__filltie
XTAP_TAPCELL_ROW_0_246 VDD VSS gf180mcu_fd_sc_mcu7t5v0__filltie
XFILLER_40_117 VDD VDD VSS VSS gf180mcu_fd_sc_mcu7t5v0__fill_1
XPHY_EDGE_ROW_38_Left_160 VDD VSS gf180mcu_fd_sc_mcu7t5v0__endcap
XTAP_TAPCELL_ROW_103_872 VDD VSS gf180mcu_fd_sc_mcu7t5v0__filltie
XFILLER_119_230 VDD VDD VSS VSS gf180mcu_fd_sc_mcu7t5v0__fill_2
XFILLER_119_241 VDD VDD VSS VSS gf180mcu_fd_sc_mcu7t5v0__fillcap_16
Xoutput25 _4198_/Z pga_gain_control[0] VDD VDD VSS VSS gf180mcu_fd_sc_mcu7t5v0__dlyb_1
XTAP_TAPCELL_ROW_8_302 VDD VSS gf180mcu_fd_sc_mcu7t5v0__filltie
Xoutput14 _3938_/Q PAD_PD[0] VDD VDD VSS VSS gf180mcu_fd_sc_mcu7t5v0__dlyb_1
XFILLER_48_206 VDD VDD VSS VSS gf180mcu_fd_sc_mcu7t5v0__fill_1
XFILLER_63_209 VDD VDD VSS VSS gf180mcu_fd_sc_mcu7t5v0__fill_1
XTAP_TAPCELL_ROW_14_337 VDD VSS gf180mcu_fd_sc_mcu7t5v0__filltie
XFILLER_12_353 VDD VDD VSS VSS gf180mcu_fd_sc_mcu7t5v0__fillcap_32
XFILLER_113_417 VDD VDD VSS VSS gf180mcu_fd_sc_mcu7t5v0__fill_2
XFILLER_98_128 VDD VDD VSS VSS gf180mcu_fd_sc_mcu7t5v0__fill_1
XFILLER_79_320 VDD VDD VSS VSS gf180mcu_fd_sc_mcu7t5v0__fill_1
XFILLER_94_301 VDD VDD VSS VSS gf180mcu_fd_sc_mcu7t5v0__fillcap_8
X_3080_ _3080_/A1 _3080_/A2 _3080_/B _3939_/D VDD VDD VSS VSS gf180mcu_fd_sc_mcu7t5v0__aoi21_1
XTAP_TAPCELL_ROW_109_909 VDD VSS gf180mcu_fd_sc_mcu7t5v0__filltie
X_2100_ _3840_/Q _3839_/Q _2938_/A3 VDD VDD VSS VSS gf180mcu_fd_sc_mcu7t5v0__nor2_1
X_2031_ _3822_/Q _2357_/A1 VDD VDD VSS VSS gf180mcu_fd_sc_mcu7t5v0__clkinv_1
XTAP_TAPCELL_ROW_117_953 VDD VSS gf180mcu_fd_sc_mcu7t5v0__filltie
X_3982_ _3982_/D clkload1/I _3982_/Q VDD VDD VSS VSS gf180mcu_fd_sc_mcu7t5v0__dffq_1
X_2933_ _3928_/Q _3927_/Q _2933_/A3 _3587_/B _2999_/A2 VDD VDD VSS VSS gf180mcu_fd_sc_mcu7t5v0__oai31_1
XTAP_TAPCELL_ROW_100_853 VDD VSS gf180mcu_fd_sc_mcu7t5v0__filltie
X_2864_ _2858_/B _2864_/A2 _2864_/B1 _2864_/B2 _2864_/C _2866_/B VDD VDD VSS VSS gf180mcu_fd_sc_mcu7t5v0__aoi221_1
X_2795_ _3957_/Q _3899_/Q _2795_/B _2796_/A2 VDD VDD VSS VSS gf180mcu_fd_sc_mcu7t5v0__aoi21_1
Xclkbuf_1_0__f__1538_ clkbuf_0__1538_/Z _3552_/A1 VDD VDD VSS VSS gf180mcu_fd_sc_mcu7t5v0__clkbuf_16
XFILLER_116_244 VDD VDD VSS VSS gf180mcu_fd_sc_mcu7t5v0__fill_1
Xtop_level_101 trig_out_ie_control VDD VDD VSS VSS gf180mcu_fd_sc_mcu7t5v0__tiel
Xtop_level_112 i2c_sda_out_pu_control VDD VDD VSS VSS gf180mcu_fd_sc_mcu7t5v0__tieh
XFILLER_89_117 VDD VDD VSS VSS gf180mcu_fd_sc_mcu7t5v0__fill_1
X_3416_ _3401_/I _3414_/Z _3416_/A3 _4070_/D VDD VDD VSS VSS gf180mcu_fd_sc_mcu7t5v0__nor3_1
XFILLER_97_150 VDD VDD VSS VSS gf180mcu_fd_sc_mcu7t5v0__fillcap_4
X_3347_ _4056_/Q _3345_/Z _3363_/B _3348_/B VDD VDD VSS VSS gf180mcu_fd_sc_mcu7t5v0__aoi21_1
XTAP_TAPCELL_ROW_96_830 VDD VSS gf180mcu_fd_sc_mcu7t5v0__filltie
X_3278_ _3750_/I1 _3283_/A2 wire81/Z _3279_/B VDD VDD VSS VSS gf180mcu_fd_sc_mcu7t5v0__oai21_1
XTAP_TAPCELL_ROW_28_418 VDD VSS gf180mcu_fd_sc_mcu7t5v0__filltie
X_2229_ _2229_/A1 _2229_/A2 _3797_/D VDD VDD VSS VSS gf180mcu_fd_sc_mcu7t5v0__nor2_1
XFILLER_26_423 VDD VDD VSS VSS gf180mcu_fd_sc_mcu7t5v0__fill_2
XFILLER_53_220 VDD VDD VSS VSS gf180mcu_fd_sc_mcu7t5v0__fill_1
XFILLER_53_286 VDD VDD VSS VSS gf180mcu_fd_sc_mcu7t5v0__fill_2
XTAP_TAPCELL_ROW_11_318 VDD VSS gf180mcu_fd_sc_mcu7t5v0__filltie
XFILLER_107_72 VDD VDD VSS VSS gf180mcu_fd_sc_mcu7t5v0__fill_2
XFILLER_29_294 VDD VDD VSS VSS gf180mcu_fd_sc_mcu7t5v0__fillcap_8
XFILLER_83_20 VDD VDD VSS VSS gf180mcu_fd_sc_mcu7t5v0__fill_1
XTAP_TAPCELL_ROW_114_934 VDD VSS gf180mcu_fd_sc_mcu7t5v0__filltie
XFILLER_8_132 VDD VDD VSS VSS gf180mcu_fd_sc_mcu7t5v0__fillcap_16
X_2580_ _3172_/A1 _3892_/Q _3891_/Q _3170_/A1 _2590_/A2 VDD VDD VSS VSS gf180mcu_fd_sc_mcu7t5v0__aoi22_1
X_3201_ _3754_/I1 _3206_/A2 wire81/Z _3202_/B VDD VDD VSS VSS gf180mcu_fd_sc_mcu7t5v0__oai21_1
X_3132_ _3132_/A1 _3138_/A2 _3132_/B _3963_/D VDD VDD VSS VSS gf180mcu_fd_sc_mcu7t5v0__aoi21_1
X_3063_ _3750_/I1 _3080_/A2 wire81/Z _3064_/B VDD VDD VSS VSS gf180mcu_fd_sc_mcu7t5v0__oai21_1
XFILLER_27_209 VDD VDD VSS VSS gf180mcu_fd_sc_mcu7t5v0__fill_1
XFILLER_82_326 VDD VDD VSS VSS gf180mcu_fd_sc_mcu7t5v0__fill_1
XTAP_TAPCELL_ROW_93_811 VDD VSS gf180mcu_fd_sc_mcu7t5v0__filltie
X_2014_ _3931_/Q _3064_/A1 VDD VDD VSS VSS gf180mcu_fd_sc_mcu7t5v0__clkinv_1
XFILLER_35_275 VDD VDD VSS VSS gf180mcu_fd_sc_mcu7t5v0__fillcap_4
XFILLER_50_267 VDD VDD VSS VSS gf180mcu_fd_sc_mcu7t5v0__fill_1
X_3965_ _3965_/D _4034_/CLK _3965_/Q VDD VDD VSS VSS gf180mcu_fd_sc_mcu7t5v0__dffq_1
X_3896_ _3896_/D clkload9/I _3896_/Q VDD VDD VSS VSS gf180mcu_fd_sc_mcu7t5v0__dffq_1
X_2916_ _3974_/Q _3916_/Q _2924_/A1 VDD VDD VSS VSS gf180mcu_fd_sc_mcu7t5v0__nand2_1
X_2847_ _3136_/A1 _2847_/A2 _2858_/B VDD VDD VSS VSS gf180mcu_fd_sc_mcu7t5v0__nor2_1
X_2778_ _2798_/A1 _2778_/A2 _2780_/A1 VDD VDD VSS VSS gf180mcu_fd_sc_mcu7t5v0__nand2_1
Xhold121 _4156_/Q _4157_/D VDD VDD VSS VSS gf180mcu_fd_sc_mcu7t5v0__dlyc_1
Xhold132 _3863_/Q _2076_/I VDD VDD VSS VSS gf180mcu_fd_sc_mcu7t5v0__dlyc_1
Xhold143 _4007_/Q _1938_/I VDD VDD VSS VSS gf180mcu_fd_sc_mcu7t5v0__dlyc_1
Xhold165 _3870_/Q hold165/Z VDD VDD VSS VSS gf180mcu_fd_sc_mcu7t5v0__dlyc_1
Xhold176 hold176/I _3779_/D VDD VDD VSS VSS gf180mcu_fd_sc_mcu7t5v0__dlyc_1
Xhold154 _4058_/Q hold154/Z VDD VDD VSS VSS gf180mcu_fd_sc_mcu7t5v0__dlyc_1
XFILLER_104_247 VDD VDD VSS VSS gf180mcu_fd_sc_mcu7t5v0__fill_2
Xhold198 _3826_/Q hold198/Z VDD VDD VSS VSS gf180mcu_fd_sc_mcu7t5v0__dlyc_1
Xhold187 _4168_/Q hold187/Z VDD VDD VSS VSS gf180mcu_fd_sc_mcu7t5v0__dlyc_1
XFILLER_85_142 VDD VDD VSS VSS gf180mcu_fd_sc_mcu7t5v0__fillcap_32
XFILLER_37_57 VDD VDD VSS VSS gf180mcu_fd_sc_mcu7t5v0__fill_2
XFILLER_37_68 VDD VDD VSS VSS gf180mcu_fd_sc_mcu7t5v0__fill_2
XFILLER_73_359 VDD VDD VSS VSS gf180mcu_fd_sc_mcu7t5v0__fillcap_4
XFILLER_53_23 VDD VDD VSS VSS gf180mcu_fd_sc_mcu7t5v0__fill_2
XFILLER_41_278 VDD VDD VSS VSS gf180mcu_fd_sc_mcu7t5v0__fill_2
XFILLER_1_352 VDD VDD VSS VSS gf180mcu_fd_sc_mcu7t5v0__fillcap_64
XFILLER_76_131 VDD VDD VSS VSS gf180mcu_fd_sc_mcu7t5v0__fill_2
XTAP_TAPCELL_ROW_47_535 VDD VSS gf180mcu_fd_sc_mcu7t5v0__filltie
XFILLER_17_264 VDD VDD VSS VSS gf180mcu_fd_sc_mcu7t5v0__fill_1
X_3750_ hold181/Z _3750_/I1 _3757_/S _4149_/D VDD VDD VSS VSS gf180mcu_fd_sc_mcu7t5v0__mux2_2
XTAP_TAPCELL_ROW_30_435 VDD VSS gf180mcu_fd_sc_mcu7t5v0__filltie
X_2701_ _3943_/Q _3885_/Q _2710_/A1 VDD VDD VSS VSS gf180mcu_fd_sc_mcu7t5v0__nand2_1
X_3681_ _3681_/A1 _3692_/A2 _3681_/B _4124_/D VDD VDD VSS VSS gf180mcu_fd_sc_mcu7t5v0__aoi21_1
X_2632_ _3236_/A1 _3890_/Q _3889_/Q _3234_/A1 _2633_/B2 VDD VDD VSS VSS gf180mcu_fd_sc_mcu7t5v0__oai22_1
X_2563_ _2601_/A1 _2602_/A3 _2563_/B _2568_/A2 VDD VDD VSS VSS gf180mcu_fd_sc_mcu7t5v0__oai21_1
XFILLER_99_212 VDD VDD VSS VSS gf180mcu_fd_sc_mcu7t5v0__fillcap_8
X_2494_ _2494_/I0 hold166/Z _2498_/S _3869_/D VDD VDD VSS VSS gf180mcu_fd_sc_mcu7t5v0__mux2_2
XFILLER_67_120 VDD VDD VSS VSS gf180mcu_fd_sc_mcu7t5v0__fill_2
XFILLER_67_142 VDD VDD VSS VSS gf180mcu_fd_sc_mcu7t5v0__fill_1
X_4164_ _4164_/D _4164_/CLK _4164_/Q VDD VDD VSS VSS gf180mcu_fd_sc_mcu7t5v0__dffq_1
X_3115_ _3115_/A1 _3121_/A2 _3115_/B _3955_/D VDD VDD VSS VSS gf180mcu_fd_sc_mcu7t5v0__aoi21_1
X_4095_ _4095_/D clkload7/I _4095_/Q VDD VDD VSS VSS gf180mcu_fd_sc_mcu7t5v0__dffq_1
X_3046_ hold144/Z _3676_/A2 _3046_/B1 _3046_/B2 _3047_/A2 VDD VDD VSS VSS gf180mcu_fd_sc_mcu7t5v0__aoi22_1
XFILLER_23_212 VDD VDD VSS VSS gf180mcu_fd_sc_mcu7t5v0__fill_2
XFILLER_82_189 VDD VDD VSS VSS gf180mcu_fd_sc_mcu7t5v0__fillcap_8
XFILLER_23_256 VDD VDD VSS VSS gf180mcu_fd_sc_mcu7t5v0__fill_1
XFILLER_23_234 VDD VDD VSS VSS gf180mcu_fd_sc_mcu7t5v0__fill_1
XFILLER_23_267 VDD VDD VSS VSS gf180mcu_fd_sc_mcu7t5v0__fillcap_8
XFILLER_23_15 VDD VDD VSS VSS gf180mcu_fd_sc_mcu7t5v0__fillcap_4
X_3948_ _3948_/D _4162_/CLK _3948_/Q VDD VDD VSS VSS gf180mcu_fd_sc_mcu7t5v0__dffq_1
X_3879_ _3879_/D clkload6/I _3879_/Q VDD VDD VSS VSS gf180mcu_fd_sc_mcu7t5v0__dffq_1
Xclkbuf_leaf_5__1473_ clkbuf_leaf_5__1473_/I _3536_/C VDD VDD VSS VSS gf180mcu_fd_sc_mcu7t5v0__clkbuf_8
XFILLER_14_201 VDD VDD VSS VSS gf180mcu_fd_sc_mcu7t5v0__fill_1
XTAP_TAPCELL_ROW_44_516 VDD VSS gf180mcu_fd_sc_mcu7t5v0__filltie
XFILLER_9_39 VDD VDD VSS VSS gf180mcu_fd_sc_mcu7t5v0__fill_2
XFILLER_108_372 VDD VDD VSS VSS gf180mcu_fd_sc_mcu7t5v0__fillcap_4
XFILLER_37_315 VDD VDD VSS VSS gf180mcu_fd_sc_mcu7t5v0__fill_2
XFILLER_49_142 VDD VDD VSS VSS gf180mcu_fd_sc_mcu7t5v0__fill_1
X_3802_ _3802_/D clkload3/I _3802_/Q VDD VDD VSS VSS gf180mcu_fd_sc_mcu7t5v0__dffq_1
X_1994_ _3951_/Q _3107_/A1 VDD VDD VSS VSS gf180mcu_fd_sc_mcu7t5v0__clkinv_1
XFILLER_20_237 VDD VDD VSS VSS gf180mcu_fd_sc_mcu7t5v0__fill_2
X_3733_ _3731_/C _3733_/A2 _4142_/D VDD VDD VSS VSS gf180mcu_fd_sc_mcu7t5v0__nor2_1
XFILLER_9_282 VDD VDD VSS VSS gf180mcu_fd_sc_mcu7t5v0__fillcap_16
X_3664_ _3797_/Q wire71/Z _3664_/B1 _3805_/Q _3665_/A3 VDD VDD VSS VSS gf180mcu_fd_sc_mcu7t5v0__aoi22_1
Xclkload30 _3539_/A1 clkload30/Z VDD VDD VSS VSS gf180mcu_fd_sc_mcu7t5v0__clkbuf_2
X_2615_ _3217_/A1 _3913_/Q _2616_/C VDD VDD VSS VSS gf180mcu_fd_sc_mcu7t5v0__nor2_1
X_3595_ _3790_/Q wire71/Z _3664_/B1 _3798_/Q _3596_/A3 VDD VDD VSS VSS gf180mcu_fd_sc_mcu7t5v0__aoi22_1
X_2546_ _2549_/A2 _2546_/A2 _2546_/B _2547_/A2 VDD VDD VSS VSS gf180mcu_fd_sc_mcu7t5v0__aoi21_1
XPHY_EDGE_ROW_10_Left_132 VDD VSS gf180mcu_fd_sc_mcu7t5v0__endcap
X_2477_ _2477_/A1 _2477_/A2 _2478_/I0 VDD VDD VSS VSS gf180mcu_fd_sc_mcu7t5v0__nand2_1
X_4147_ _4147_/D _4149_/CLK _4147_/Q VDD VDD VSS VSS gf180mcu_fd_sc_mcu7t5v0__dffq_1
XFILLER_55_101 VDD VDD VSS VSS gf180mcu_fd_sc_mcu7t5v0__fill_1
X_4078_ _4078_/D _4079_/CLK _4078_/Q VDD VDD VSS VSS gf180mcu_fd_sc_mcu7t5v0__dffq_1
XFILLER_55_156 VDD VDD VSS VSS gf180mcu_fd_sc_mcu7t5v0__fill_1
XFILLER_36_370 VDD VDD VSS VSS gf180mcu_fd_sc_mcu7t5v0__fill_2
X_3029_ _3940_/Q _3060_/A1 _3088_/A1 _3943_/Q _3030_/A4 VDD VDD VSS VSS gf180mcu_fd_sc_mcu7t5v0__aoi22_1
XFILLER_70_104 VDD VDD VSS VSS gf180mcu_fd_sc_mcu7t5v0__fill_1
XFILLER_51_340 VDD VDD VSS VSS gf180mcu_fd_sc_mcu7t5v0__fill_1
Xclkload2 clkload2/I clkload2/ZN VDD VDD VSS VSS gf180mcu_fd_sc_mcu7t5v0__inv_2
XFILLER_119_4 VDD VDD VSS VSS gf180mcu_fd_sc_mcu7t5v0__fill_1
XFILLER_59_88 VDD VDD VSS VSS gf180mcu_fd_sc_mcu7t5v0__fillcap_4
XFILLER_78_237 VDD VDD VSS VSS gf180mcu_fd_sc_mcu7t5v0__fillcap_8
XFILLER_115_72 VDD VDD VSS VSS gf180mcu_fd_sc_mcu7t5v0__fillcap_16
XFILLER_115_61 VDD VDD VSS VSS gf180mcu_fd_sc_mcu7t5v0__fill_1
Xclkbuf_leaf_22_ext_clk_in clkbuf_leaf_1_ext_clk_in/I _4017_/CLK VDD VDD VSS VSS gf180mcu_fd_sc_mcu7t5v0__clkbuf_8
XTAP_TAPCELL_ROW_89_788 VDD VSS gf180mcu_fd_sc_mcu7t5v0__filltie
Xload_slew36 _2242_/A2 _2155_/A2 VDD VDD VSS VSS gf180mcu_fd_sc_mcu7t5v0__buf_4
XFILLER_27_381 VDD VDD VSS VSS gf180mcu_fd_sc_mcu7t5v0__fillcap_4
XFILLER_42_351 VDD VDD VSS VSS gf180mcu_fd_sc_mcu7t5v0__fillcap_4
XFILLER_91_53 VDD VDD VSS VSS gf180mcu_fd_sc_mcu7t5v0__fillcap_16
XFILLER_42_384 VDD VDD VSS VSS gf180mcu_fd_sc_mcu7t5v0__fill_1
X_2400_ _3878_/Q _2383_/I _2400_/B1 _3844_/Q _2401_/I VDD VDD VSS VSS gf180mcu_fd_sc_mcu7t5v0__aoi22_1
X_3380_ _3707_/A1 _4074_/Q _4065_/Q _3683_/A1 _3380_/C _3383_/A3 VDD VDD VSS VSS gf180mcu_fd_sc_mcu7t5v0__oai221_1
XFILLER_111_312 VDD VDD VSS VSS gf180mcu_fd_sc_mcu7t5v0__fillcap_8
X_2331_ _2367_/A1 _2331_/A2 _2331_/B _2331_/C _2336_/A1 VDD VDD VSS VSS gf180mcu_fd_sc_mcu7t5v0__oai211_1
X_2262_ _2377_/A1 _3836_/Q _2376_/A1 _2345_/B VDD VDD VSS VSS gf180mcu_fd_sc_mcu7t5v0__nor3_1
X_4001_ _4001_/D _4170_/CLK _4001_/Q VDD VDD VSS VSS gf180mcu_fd_sc_mcu7t5v0__dffq_1
X_2193_ _2193_/A1 _2193_/A2 _3784_/D VDD VDD VSS VSS gf180mcu_fd_sc_mcu7t5v0__nor2_1
XFILLER_25_318 VDD VDD VSS VSS gf180mcu_fd_sc_mcu7t5v0__fill_2
XTAP_TAPCELL_ROW_63_633 VDD VSS gf180mcu_fd_sc_mcu7t5v0__filltie
X_3716_ _3756_/A1 _3699_/Z _3716_/B _4138_/D VDD VDD VSS VSS gf180mcu_fd_sc_mcu7t5v0__aoi21_1
X_1977_ _3968_/Q _3143_/A1 VDD VDD VSS VSS gf180mcu_fd_sc_mcu7t5v0__clkinv_1
X_3647_ _4198_/I _3748_/A1 _3679_/A1 _4129_/Q _3649_/A2 VDD VDD VSS VSS gf180mcu_fd_sc_mcu7t5v0__aoi22_1
X_3578_ _3578_/A1 _3578_/A2 _3578_/B _3579_/B _4111_/D VDD VDD VSS VSS gf180mcu_fd_sc_mcu7t5v0__aoi211_1
X_2529_ _3873_/Q _3874_/Q _2529_/A3 _2529_/Z VDD VDD VSS VSS gf180mcu_fd_sc_mcu7t5v0__and3_1
XFILLER_29_69 VDD VDD VSS VSS gf180mcu_fd_sc_mcu7t5v0__fill_1
XTAP_TAPCELL_ROW_86_769 VDD VSS gf180mcu_fd_sc_mcu7t5v0__filltie
XFILLER_43_137 VDD VDD VSS VSS gf180mcu_fd_sc_mcu7t5v0__fill_2
XFILLER_10_71 VDD VDD VSS VSS gf180mcu_fd_sc_mcu7t5v0__fill_1
XTAP_TAPCELL_ROW_77_714 VDD VSS gf180mcu_fd_sc_mcu7t5v0__filltie
XFILLER_34_104 VDD VDD VSS VSS gf180mcu_fd_sc_mcu7t5v0__fill_1
XFILLER_74_295 VDD VDD VSS VSS gf180mcu_fd_sc_mcu7t5v0__fillcap_4
XTAP_TAPCELL_ROW_17_357 VDD VSS gf180mcu_fd_sc_mcu7t5v0__filltie
XTAP_TAPCELL_ROW_60_614 VDD VSS gf180mcu_fd_sc_mcu7t5v0__filltie
X_2880_ _2885_/B _2884_/B VDD VDD VSS VSS gf180mcu_fd_sc_mcu7t5v0__clkinv_1
X_1900_ _4073_/Q _3374_/B1 VDD VDD VSS VSS gf180mcu_fd_sc_mcu7t5v0__clkinv_1
X_3501_ _4089_/Q _3513_/A2 _3536_/A2 _3506_/A2 _3503_/A1 VDD VDD VSS VSS gf180mcu_fd_sc_mcu7t5v0__aoi22_1
X_3432_ _3430_/Z _3432_/A2 _4076_/D VDD VDD VSS VSS gf180mcu_fd_sc_mcu7t5v0__nor2_1
X_3363_ _4061_/Q _3360_/Z _3363_/B _3364_/B VDD VDD VSS VSS gf180mcu_fd_sc_mcu7t5v0__aoi21_1
XFILLER_111_142 VDD VDD VSS VSS gf180mcu_fd_sc_mcu7t5v0__fillcap_64
X_2314_ _2314_/I _2331_/B VDD VDD VSS VSS gf180mcu_fd_sc_mcu7t5v0__clkinv_1
XFILLER_57_207 VDD VDD VSS VSS gf180mcu_fd_sc_mcu7t5v0__fill_2
X_3294_ _4105_/Q _3547_/B _3395_/A1 VDD VDD VSS VSS gf180mcu_fd_sc_mcu7t5v0__nand2_1
X_2245_ _4102_/Q _2248_/A2 _2247_/A1 VDD VDD VSS VSS gf180mcu_fd_sc_mcu7t5v0__nor2_1
X_2176_ hold175/Z _2242_/A2 _2178_/A1 VDD VDD VSS VSS gf180mcu_fd_sc_mcu7t5v0__nor2_1
XFILLER_53_402 VDD VDD VSS VSS gf180mcu_fd_sc_mcu7t5v0__fillcap_4
XFILLER_65_273 VDD VDD VSS VSS gf180mcu_fd_sc_mcu7t5v0__fillcap_4
XTAP_TAPCELL_ROW_0_247 VDD VSS gf180mcu_fd_sc_mcu7t5v0__filltie
XFILLER_80_243 VDD VDD VSS VSS gf180mcu_fd_sc_mcu7t5v0__fill_2
XTAP_TAPCELL_ROW_103_873 VDD VSS gf180mcu_fd_sc_mcu7t5v0__filltie
XFILLER_119_275 VDD VDD VSS VSS gf180mcu_fd_sc_mcu7t5v0__fillcap_4
Xoutput15 _3937_/Q PAD_PD[1] VDD VDD VSS VSS gf180mcu_fd_sc_mcu7t5v0__dlyb_1
XTAP_TAPCELL_ROW_8_303 VDD VSS gf180mcu_fd_sc_mcu7t5v0__filltie
XPHY_EDGE_ROW_1_Right_1 VDD VSS gf180mcu_fd_sc_mcu7t5v0__endcap
Xoutput26 _4199_/Z pga_gain_control[1] VDD VDD VSS VSS gf180mcu_fd_sc_mcu7t5v0__dlyb_1
XFILLER_88_310 VDD VDD VSS VSS gf180mcu_fd_sc_mcu7t5v0__fillcap_4
XFILLER_88_343 VDD VDD VSS VSS gf180mcu_fd_sc_mcu7t5v0__fill_1
XFILLER_88_387 VDD VDD VSS VSS gf180mcu_fd_sc_mcu7t5v0__fill_2
XFILLER_56_295 VDD VDD VSS VSS gf180mcu_fd_sc_mcu7t5v0__fill_2
XFILLER_16_159 VDD VDD VSS VSS gf180mcu_fd_sc_mcu7t5v0__fillcap_4
XFILLER_24_181 VDD VDD VSS VSS gf180mcu_fd_sc_mcu7t5v0__fill_1
XTAP_TAPCELL_ROW_14_338 VDD VSS gf180mcu_fd_sc_mcu7t5v0__filltie
XFILLER_12_387 VDD VDD VSS VSS gf180mcu_fd_sc_mcu7t5v0__fillcap_32
XTAP_TAPCELL_ROW_22_382 VDD VSS gf180mcu_fd_sc_mcu7t5v0__filltie
XFILLER_98_107 VDD VDD VSS VSS gf180mcu_fd_sc_mcu7t5v0__fill_2
XFILLER_79_376 VDD VDD VSS VSS gf180mcu_fd_sc_mcu7t5v0__fill_1
XFILLER_97_96 VDD VDD VSS VSS gf180mcu_fd_sc_mcu7t5v0__fill_1
X_2030_ _3823_/Q _2360_/A1 VDD VDD VSS VSS gf180mcu_fd_sc_mcu7t5v0__clkinv_1
XTAP_TAPCELL_ROW_117_954 VDD VSS gf180mcu_fd_sc_mcu7t5v0__filltie
XFILLER_22_107 VDD VDD VSS VSS gf180mcu_fd_sc_mcu7t5v0__fillcap_4
X_3981_ _3981_/D _4017_/CLK _3981_/Q VDD VDD VSS VSS gf180mcu_fd_sc_mcu7t5v0__dffq_1
XFILLER_62_243 VDD VDD VSS VSS gf180mcu_fd_sc_mcu7t5v0__fill_2
X_2932_ _3667_/C2 _2936_/A2 _2933_/A3 VDD VDD VSS VSS gf180mcu_fd_sc_mcu7t5v0__nand2_1
XFILLER_30_162 VDD VDD VSS VSS gf180mcu_fd_sc_mcu7t5v0__fill_1
XTAP_TAPCELL_ROW_100_854 VDD VSS gf180mcu_fd_sc_mcu7t5v0__filltie
X_2863_ _2837_/B _2865_/A3 _2863_/B _2863_/C _2864_/B2 VDD VDD VSS VSS gf180mcu_fd_sc_mcu7t5v0__oai211_1
X_2794_ _3958_/Q _3900_/Q _2802_/A4 VDD VDD VSS VSS gf180mcu_fd_sc_mcu7t5v0__xnor2_1
XFILLER_7_72 VDD VDD VSS VSS gf180mcu_fd_sc_mcu7t5v0__fillcap_32
Xclkbuf_1_0__f__1468_ clkbuf_0__1468_/Z _3462_/A1 VDD VDD VSS VSS gf180mcu_fd_sc_mcu7t5v0__clkbuf_16
Xtop_level_102 trig_out_pu_control VDD VDD VSS VSS gf180mcu_fd_sc_mcu7t5v0__tiel
Xtop_level_113 nrst_in_pu_control VDD VDD VSS VSS gf180mcu_fd_sc_mcu7t5v0__tieh
X_3415_ _4069_/Q _3410_/Z _4070_/Q _3416_/A3 VDD VDD VSS VSS gf180mcu_fd_sc_mcu7t5v0__aoi21_1
X_3346_ _3363_/B _3346_/A2 _3345_/Z _4055_/D VDD VDD VSS VSS gf180mcu_fd_sc_mcu7t5v0__nor3_1
XTAP_TAPCELL_ROW_96_831 VDD VSS gf180mcu_fd_sc_mcu7t5v0__filltie
XFILLER_85_368 VDD VDD VSS VSS gf180mcu_fd_sc_mcu7t5v0__fill_1
X_3277_ _3277_/A1 _3283_/A2 _3277_/B _4031_/D VDD VDD VSS VSS gf180mcu_fd_sc_mcu7t5v0__aoi21_1
XTAP_TAPCELL_ROW_28_419 VDD VSS gf180mcu_fd_sc_mcu7t5v0__filltie
X_2228_ _3797_/Q _2111_/Z _3746_/B _2229_/A2 VDD VDD VSS VSS gf180mcu_fd_sc_mcu7t5v0__oai21_1
XFILLER_93_390 VDD VDD VSS VSS gf180mcu_fd_sc_mcu7t5v0__fill_1
X_2159_ _3773_/Q _2243_/A2 _3746_/B _2160_/A2 VDD VDD VSS VSS gf180mcu_fd_sc_mcu7t5v0__oai21_1
XFILLER_53_298 VDD VDD VSS VSS gf180mcu_fd_sc_mcu7t5v0__fill_2
XTAP_TAPCELL_ROW_11_319 VDD VSS gf180mcu_fd_sc_mcu7t5v0__filltie
XFILLER_21_195 VDD VDD VSS VSS gf180mcu_fd_sc_mcu7t5v0__fill_2
XFILLER_107_212 VDD VDD VSS VSS gf180mcu_fd_sc_mcu7t5v0__fillcap_4
XPHY_EDGE_ROW_2_Left_124 VDD VSS gf180mcu_fd_sc_mcu7t5v0__endcap
XFILLER_107_267 VDD VDD VSS VSS gf180mcu_fd_sc_mcu7t5v0__fill_1
XFILLER_29_251 VDD VDD VSS VSS gf180mcu_fd_sc_mcu7t5v0__fill_1
XFILLER_91_327 VDD VDD VSS VSS gf180mcu_fd_sc_mcu7t5v0__fill_1
XTAP_TAPCELL_ROW_114_935 VDD VSS gf180mcu_fd_sc_mcu7t5v0__filltie
XFILLER_83_76 VDD VDD VSS VSS gf180mcu_fd_sc_mcu7t5v0__fill_1
XFILLER_8_111 VDD VDD VSS VSS gf180mcu_fd_sc_mcu7t5v0__fill_2
XFILLER_8_188 VDD VDD VSS VSS gf180mcu_fd_sc_mcu7t5v0__fill_1
XPHY_EDGE_ROW_57_Left_179 VDD VSS gf180mcu_fd_sc_mcu7t5v0__endcap
X_3200_ _3200_/A1 _3206_/A2 _3200_/B _3995_/D VDD VDD VSS VSS gf180mcu_fd_sc_mcu7t5v0__aoi21_1
X_3131_ wire90/Z _3138_/A2 wire81/Z _3132_/B VDD VDD VSS VSS gf180mcu_fd_sc_mcu7t5v0__oai21_1
XPHY_EDGE_ROW_66_Left_188 VDD VSS gf180mcu_fd_sc_mcu7t5v0__endcap
X_3062_ _3062_/A1 _3082_/A2 _3062_/B _3930_/D VDD VDD VSS VSS gf180mcu_fd_sc_mcu7t5v0__aoi21_1
XTAP_TAPCELL_ROW_93_812 VDD VSS gf180mcu_fd_sc_mcu7t5v0__filltie
X_2013_ _2013_/I _3066_/A1 VDD VDD VSS VSS gf180mcu_fd_sc_mcu7t5v0__clkinv_1
XFILLER_23_416 VDD VDD VSS VSS gf180mcu_fd_sc_mcu7t5v0__fillcap_4
XFILLER_50_235 VDD VDD VSS VSS gf180mcu_fd_sc_mcu7t5v0__fill_1
X_3964_ _3964_/D _4155_/CLK _3964_/Q VDD VDD VSS VSS gf180mcu_fd_sc_mcu7t5v0__dffq_1
X_3895_ _3895_/D clkload9/I _3895_/Q VDD VDD VSS VSS gf180mcu_fd_sc_mcu7t5v0__dffq_1
X_2915_ _3155_/A1 _2915_/A2 _2923_/A3 VDD VDD VSS VSS gf180mcu_fd_sc_mcu7t5v0__nand2_1
XPHY_EDGE_ROW_75_Left_197 VDD VSS gf180mcu_fd_sc_mcu7t5v0__endcap
X_2846_ _2929_/A1 _2845_/Z _3906_/D VDD VDD VSS VSS gf180mcu_fd_sc_mcu7t5v0__nor2_1
X_2777_ _2771_/B _2805_/A2 _2779_/C _2778_/A2 VDD VDD VSS VSS gf180mcu_fd_sc_mcu7t5v0__oai21_1
Xhold144 _3926_/Q hold144/Z VDD VDD VSS VSS gf180mcu_fd_sc_mcu7t5v0__dlyc_1
Xhold133 _3938_/Q _2007_/I VDD VDD VSS VSS gf180mcu_fd_sc_mcu7t5v0__dlyc_1
Xhold122 _4170_/Q _4168_/D VDD VDD VSS VSS gf180mcu_fd_sc_mcu7t5v0__dlyc_1
Xhold177 _4012_/Q _1933_/I VDD VDD VSS VSS gf180mcu_fd_sc_mcu7t5v0__dlyc_1
Xhold166 _3869_/Q hold166/Z VDD VDD VSS VSS gf180mcu_fd_sc_mcu7t5v0__dlyc_1
Xhold155 hold155/I _3777_/D VDD VDD VSS VSS gf180mcu_fd_sc_mcu7t5v0__dlyc_1
Xhold188 _3927_/Q hold188/Z VDD VDD VSS VSS gf180mcu_fd_sc_mcu7t5v0__dlyc_1
Xhold199 _3994_/Q _1951_/I VDD VDD VSS VSS gf180mcu_fd_sc_mcu7t5v0__dlyc_1
XFILLER_58_302 VDD VDD VSS VSS gf180mcu_fd_sc_mcu7t5v0__fill_2
XFILLER_85_110 VDD VDD VSS VSS gf180mcu_fd_sc_mcu7t5v0__fillcap_16
X_3329_ hold233/Z _3327_/Z _3331_/A2 VDD VDD VSS VSS gf180mcu_fd_sc_mcu7t5v0__nor2_1
XFILLER_73_316 VDD VDD VSS VSS gf180mcu_fd_sc_mcu7t5v0__fill_1
XFILLER_26_210 VDD VDD VSS VSS gf180mcu_fd_sc_mcu7t5v0__fillcap_16
XFILLER_73_349 VDD VDD VSS VSS gf180mcu_fd_sc_mcu7t5v0__fill_1
XFILLER_26_243 VDD VDD VSS VSS gf180mcu_fd_sc_mcu7t5v0__fill_2
XTAP_TAPCELL_ROW_111_916 VDD VSS gf180mcu_fd_sc_mcu7t5v0__filltie
XFILLER_5_114 VDD VDD VSS VSS gf180mcu_fd_sc_mcu7t5v0__fill_1
XFILLER_118_83 VDD VDD VSS VSS gf180mcu_fd_sc_mcu7t5v0__fillcap_8
XFILLER_94_31 VDD VDD VSS VSS gf180mcu_fd_sc_mcu7t5v0__fillcap_4
XTAP_TAPCELL_ROW_47_536 VDD VSS gf180mcu_fd_sc_mcu7t5v0__filltie
XFILLER_17_298 VDD VDD VSS VSS gf180mcu_fd_sc_mcu7t5v0__fillcap_4
XTAP_TAPCELL_ROW_55_580 VDD VSS gf180mcu_fd_sc_mcu7t5v0__filltie
XFILLER_20_419 VDD VDD VSS VSS gf180mcu_fd_sc_mcu7t5v0__fillcap_4
X_2700_ _2700_/A1 _2700_/A2 wire81/Z _2929_/A1 VDD VDD VSS VSS gf180mcu_fd_sc_mcu7t5v0__oai21_2
X_3680_ wire94/Z _3692_/A2 _3746_/B _3681_/B VDD VDD VSS VSS gf180mcu_fd_sc_mcu7t5v0__oai21_1
X_2631_ _3234_/A1 _3889_/Q _2631_/B1 _2631_/B2 _2633_/B1 VDD VDD VSS VSS gf180mcu_fd_sc_mcu7t5v0__aoi22_1
X_2562_ _3194_/A1 _3902_/Q _3901_/Q _3192_/A1 _2602_/A3 VDD VDD VSS VSS gf180mcu_fd_sc_mcu7t5v0__aoi22_1
X_2493_ _2493_/A1 _2493_/A2 _2494_/I0 VDD VDD VSS VSS gf180mcu_fd_sc_mcu7t5v0__nand2_1
XFILLER_87_419 VDD VDD VSS VSS gf180mcu_fd_sc_mcu7t5v0__fill_1
XFILLER_99_257 VDD VDD VSS VSS gf180mcu_fd_sc_mcu7t5v0__fill_1
XFILLER_99_279 VDD VDD VSS VSS gf180mcu_fd_sc_mcu7t5v0__fill_1
X_4163_ _4163_/D clkload9/I _4163_/Q VDD VDD VSS VSS gf180mcu_fd_sc_mcu7t5v0__dffq_1
X_3114_ wire90/I _3121_/A2 _3256_/B _3115_/B VDD VDD VSS VSS gf180mcu_fd_sc_mcu7t5v0__oai21_1
X_4094_ _4094_/D clkload5/I _4094_/Q VDD VDD VSS VSS gf180mcu_fd_sc_mcu7t5v0__dffq_1
X_3045_ _3045_/A1 _3045_/A2 _3045_/A3 _3046_/B2 VDD VDD VSS VSS gf180mcu_fd_sc_mcu7t5v0__nand3_1
XFILLER_70_308 VDD VDD VSS VSS gf180mcu_fd_sc_mcu7t5v0__fill_1
XFILLER_23_279 VDD VDD VSS VSS gf180mcu_fd_sc_mcu7t5v0__fill_1
X_3947_ _3947_/D _4162_/CLK _3947_/Q VDD VDD VSS VSS gf180mcu_fd_sc_mcu7t5v0__dffq_1
XPHY_EDGE_ROW_83_Left_205 VDD VSS gf180mcu_fd_sc_mcu7t5v0__endcap
X_3878_ _3878_/D clkload7/I _3878_/Q VDD VDD VSS VSS gf180mcu_fd_sc_mcu7t5v0__dffq_1
X_2829_ _2827_/I _2829_/A2 _2829_/Z VDD VDD VSS VSS gf180mcu_fd_sc_mcu7t5v0__xor2_1
XPHY_EDGE_ROW_92_Left_214 VDD VSS gf180mcu_fd_sc_mcu7t5v0__endcap
Xclkbuf_leaf_12_ext_clk_in clkload0/I _4142_/CLK VDD VDD VSS VSS gf180mcu_fd_sc_mcu7t5v0__clkbuf_8
XFILLER_58_165 VDD VDD VSS VSS gf180mcu_fd_sc_mcu7t5v0__fill_2
XFILLER_100_251 VDD VDD VSS VSS gf180mcu_fd_sc_mcu7t5v0__fillcap_16
XFILLER_73_124 VDD VDD VSS VSS gf180mcu_fd_sc_mcu7t5v0__fill_1
XFILLER_73_157 VDD VDD VSS VSS gf180mcu_fd_sc_mcu7t5v0__fill_2
XTAP_TAPCELL_ROW_44_517 VDD VSS gf180mcu_fd_sc_mcu7t5v0__filltie
XFILLER_120_84 VDD VDD VSS VSS gf180mcu_fd_sc_mcu7t5v0__fillcap_16
XFILLER_120_51 VDD VDD VSS VSS gf180mcu_fd_sc_mcu7t5v0__fillcap_16
XFILLER_6_423 VDD VDD VSS VSS gf180mcu_fd_sc_mcu7t5v0__fill_2
XFILLER_108_351 VDD VDD VSS VSS gf180mcu_fd_sc_mcu7t5v0__fill_2
XFILLER_108_362 VDD VDD VSS VSS gf180mcu_fd_sc_mcu7t5v0__fill_2
XFILLER_89_64 VDD VDD VSS VSS gf180mcu_fd_sc_mcu7t5v0__fillcap_4
XFILLER_1_150 VDD VDD VSS VSS gf180mcu_fd_sc_mcu7t5v0__fillcap_4
XFILLER_69_419 VDD VDD VSS VSS gf180mcu_fd_sc_mcu7t5v0__fill_1
XFILLER_89_290 VDD VDD VSS VSS gf180mcu_fd_sc_mcu7t5v0__fill_2
XFILLER_96_238 VDD VDD VSS VSS gf180mcu_fd_sc_mcu7t5v0__fillcap_4
XFILLER_37_349 VDD VDD VSS VSS gf180mcu_fd_sc_mcu7t5v0__fill_1
XFILLER_52_319 VDD VDD VSS VSS gf180mcu_fd_sc_mcu7t5v0__fill_1
X_3801_ _3801_/D clkload3/I _3801_/Q VDD VDD VSS VSS gf180mcu_fd_sc_mcu7t5v0__dffq_1
X_1993_ _3952_/Q _3109_/A1 VDD VDD VSS VSS gf180mcu_fd_sc_mcu7t5v0__clkinv_1
XFILLER_118_104 VDD VDD VSS VSS gf180mcu_fd_sc_mcu7t5v0__fill_1
X_3732_ _3854_/Q _3725_/Z _3732_/B1 _4142_/Q _3733_/A2 VDD VDD VSS VSS gf180mcu_fd_sc_mcu7t5v0__aoi22_1
Xclkload20 _4104_/CLK clkload20/ZN VDD VDD VSS VSS gf180mcu_fd_sc_mcu7t5v0__inv_2
X_3663_ _3789_/Q _3663_/A2 _3663_/B1 _3773_/Q _3665_/A2 VDD VDD VSS VSS gf180mcu_fd_sc_mcu7t5v0__aoi22_1
Xclkload31 _3534_/B clkload31/Z VDD VDD VSS VSS gf180mcu_fd_sc_mcu7t5v0__clkbuf_2
X_2614_ _4003_/Q _2684_/A2 _2887_/A2 _4002_/Q _2621_/B VDD VDD VSS VSS gf180mcu_fd_sc_mcu7t5v0__oai22_1
XFILLER_114_321 VDD VDD VSS VSS gf180mcu_fd_sc_mcu7t5v0__fill_2
X_3594_ _3758_/Q _3662_/A2 _3662_/B1 _3774_/Q _3596_/A2 VDD VDD VSS VSS gf180mcu_fd_sc_mcu7t5v0__aoi22_1
X_2545_ _3876_/Q _3875_/Q _3877_/Q _2529_/Z _2546_/A2 VDD VDD VSS VSS gf180mcu_fd_sc_mcu7t5v0__nand4_1
XFILLER_114_387 VDD VDD VSS VSS gf180mcu_fd_sc_mcu7t5v0__fill_2
X_2476_ _4116_/Q _3919_/Q _2496_/B _2477_/A2 VDD VDD VSS VSS gf180mcu_fd_sc_mcu7t5v0__oai21_1
X_4146_ _4146_/D _4164_/CLK _4146_/Q VDD VDD VSS VSS gf180mcu_fd_sc_mcu7t5v0__dffq_1
XFILLER_83_422 VDD VDD VSS VSS gf180mcu_fd_sc_mcu7t5v0__fillcap_4
XFILLER_95_282 VDD VDD VSS VSS gf180mcu_fd_sc_mcu7t5v0__fillcap_16
X_4077_ _4077_/D _4079_/CLK _4077_/Q VDD VDD VSS VSS gf180mcu_fd_sc_mcu7t5v0__dffq_1
X_3028_ _3959_/Q _3122_/A1 _3057_/A1 _3939_/Q _3030_/A3 VDD VDD VSS VSS gf180mcu_fd_sc_mcu7t5v0__aoi22_1
XFILLER_34_59 VDD VDD VSS VSS gf180mcu_fd_sc_mcu7t5v0__fill_1
XFILLER_7_209 VDD VDD VSS VSS gf180mcu_fd_sc_mcu7t5v0__fill_1
Xclkload3 clkload3/I clkload3/Z VDD VDD VSS VSS gf180mcu_fd_sc_mcu7t5v0__clkbuf_2
XFILLER_50_25 VDD VDD VSS VSS gf180mcu_fd_sc_mcu7t5v0__fillcap_8
XFILLER_105_321 VDD VDD VSS VSS gf180mcu_fd_sc_mcu7t5v0__fill_1
XFILLER_105_332 VDD VDD VSS VSS gf180mcu_fd_sc_mcu7t5v0__fill_2
XTAP_TAPCELL_ROW_6_286 VDD VSS gf180mcu_fd_sc_mcu7t5v0__filltie
XTAP_TAPCELL_ROW_89_789 VDD VSS gf180mcu_fd_sc_mcu7t5v0__filltie
Xload_slew37 _2248_/A2 _2242_/A2 VDD VDD VSS VSS gf180mcu_fd_sc_mcu7t5v0__buf_4
XFILLER_27_393 VDD VDD VSS VSS gf180mcu_fd_sc_mcu7t5v0__fillcap_16
XFILLER_61_138 VDD VDD VSS VSS gf180mcu_fd_sc_mcu7t5v0__fill_2
XFILLER_10_271 VDD VDD VSS VSS gf180mcu_fd_sc_mcu7t5v0__fill_2
X_2330_ _2273_/Z _2323_/C _2338_/A1 VDD VDD VSS VSS gf180mcu_fd_sc_mcu7t5v0__nor2_1
X_2261_ _2377_/A1 _2260_/Z _2345_/A1 VDD VDD VSS VSS gf180mcu_fd_sc_mcu7t5v0__nand2_1
XFILLER_111_379 VDD VDD VSS VSS gf180mcu_fd_sc_mcu7t5v0__fill_2
XFILLER_84_219 VDD VDD VSS VSS gf180mcu_fd_sc_mcu7t5v0__fill_2
X_4000_ _4000_/D _4170_/CLK _4000_/Q VDD VDD VSS VSS gf180mcu_fd_sc_mcu7t5v0__dffq_1
XFILLER_65_422 VDD VDD VSS VSS gf180mcu_fd_sc_mcu7t5v0__fillcap_4
X_2192_ _3784_/Q _2243_/A2 _3746_/B _2193_/A2 VDD VDD VSS VSS gf180mcu_fd_sc_mcu7t5v0__oai21_1
XFILLER_1_74 VDD VDD VSS VSS gf180mcu_fd_sc_mcu7t5v0__fill_1
XFILLER_18_382 VDD VDD VSS VSS gf180mcu_fd_sc_mcu7t5v0__fill_2
XFILLER_33_352 VDD VDD VSS VSS gf180mcu_fd_sc_mcu7t5v0__fill_2
X_1976_ _3969_/Q _3145_/A1 VDD VDD VSS VSS gf180mcu_fd_sc_mcu7t5v0__clkinv_1
X_3715_ _4138_/Q _3699_/Z _3746_/B _3716_/B VDD VDD VSS VSS gf180mcu_fd_sc_mcu7t5v0__oai21_1
X_3646_ _3667_/C2 _3646_/A2 _3649_/A1 VDD VDD VSS VSS gf180mcu_fd_sc_mcu7t5v0__nand2_1
X_3577_ _4141_/Q _3583_/A1 _3578_/B VDD VDD VSS VSS gf180mcu_fd_sc_mcu7t5v0__nor2_1
XFILLER_114_140 VDD VDD VSS VSS gf180mcu_fd_sc_mcu7t5v0__fill_2
X_2528_ _3874_/Q _2522_/Z _2531_/A2 VDD VDD VSS VSS gf180mcu_fd_sc_mcu7t5v0__nor2_1
XFILLER_29_26 VDD VDD VSS VSS gf180mcu_fd_sc_mcu7t5v0__fillcap_4
XFILLER_102_346 VDD VDD VSS VSS gf180mcu_fd_sc_mcu7t5v0__fillcap_16
X_2459_ _2459_/A1 _3815_/Q _2462_/B _2549_/C VDD VDD VSS VSS gf180mcu_fd_sc_mcu7t5v0__aoi21_1
XFILLER_28_124 VDD VDD VSS VSS gf180mcu_fd_sc_mcu7t5v0__fill_2
X_4129_ _4129_/D _4155_/CLK _4129_/Q VDD VDD VSS VSS gf180mcu_fd_sc_mcu7t5v0__dffq_1
XFILLER_28_179 VDD VDD VSS VSS gf180mcu_fd_sc_mcu7t5v0__fill_1
XFILLER_45_14 VDD VDD VSS VSS gf180mcu_fd_sc_mcu7t5v0__fillcap_4
XFILLER_83_274 VDD VDD VSS VSS gf180mcu_fd_sc_mcu7t5v0__fillcap_4
XFILLER_45_69 VDD VDD VSS VSS gf180mcu_fd_sc_mcu7t5v0__fill_1
XFILLER_3_212 VDD VDD VSS VSS gf180mcu_fd_sc_mcu7t5v0__fillcap_4
Xclkbuf_leaf_2_ext_clk_in clkload0/I _4166_/CLK VDD VDD VSS VSS gf180mcu_fd_sc_mcu7t5v0__clkbuf_8
XFILLER_120_143 VDD VDD VSS VSS gf180mcu_fd_sc_mcu7t5v0__fill_2
XFILLER_47_422 VDD VDD VSS VSS gf180mcu_fd_sc_mcu7t5v0__fillcap_4
XTAP_TAPCELL_ROW_77_715 VDD VSS gf180mcu_fd_sc_mcu7t5v0__filltie
XFILLER_86_98 VDD VDD VSS VSS gf180mcu_fd_sc_mcu7t5v0__fillcap_4
XFILLER_15_352 VDD VDD VSS VSS gf180mcu_fd_sc_mcu7t5v0__fillcap_64
XFILLER_30_311 VDD VDD VSS VSS gf180mcu_fd_sc_mcu7t5v0__fillcap_4
XTAP_TAPCELL_ROW_60_615 VDD VSS gf180mcu_fd_sc_mcu7t5v0__filltie
X_3500_ _4089_/Q _3496_/Z _3506_/A2 VDD VDD VSS VSS gf180mcu_fd_sc_mcu7t5v0__nand2_1
X_3431_ _4076_/Q _3428_/Z _3439_/B _3432_/A2 VDD VDD VSS VSS gf180mcu_fd_sc_mcu7t5v0__oai21_1
X_3362_ _4061_/Q _3360_/Z _3366_/A2 VDD VDD VSS VSS gf180mcu_fd_sc_mcu7t5v0__nand2_1
X_2313_ _2339_/A1 _2360_/A2 _2314_/I VDD VDD VSS VSS gf180mcu_fd_sc_mcu7t5v0__nand2_1
XFILLER_97_311 VDD VDD VSS VSS gf180mcu_fd_sc_mcu7t5v0__fillcap_4
XFILLER_97_333 VDD VDD VSS VSS gf180mcu_fd_sc_mcu7t5v0__fill_2
X_3293_ _4140_/Q _3731_/C _3552_/C VDD VDD VSS VSS gf180mcu_fd_sc_mcu7t5v0__or2_1
XFILLER_97_377 VDD VDD VSS VSS gf180mcu_fd_sc_mcu7t5v0__fill_2
X_2244_ _2244_/A1 _2244_/A2 _3803_/D VDD VDD VSS VSS gf180mcu_fd_sc_mcu7t5v0__nor2_1
X_2175_ _2175_/A1 _2175_/A2 _3778_/D VDD VDD VSS VSS gf180mcu_fd_sc_mcu7t5v0__nor2_1
XFILLER_25_116 VDD VDD VSS VSS gf180mcu_fd_sc_mcu7t5v0__fillcap_16
XTAP_TAPCELL_ROW_0_248 VDD VSS gf180mcu_fd_sc_mcu7t5v0__filltie
XFILLER_80_211 VDD VDD VSS VSS gf180mcu_fd_sc_mcu7t5v0__fill_2
XFILLER_80_255 VDD VDD VSS VSS gf180mcu_fd_sc_mcu7t5v0__fillcap_4
XFILLER_21_377 VDD VDD VSS VSS gf180mcu_fd_sc_mcu7t5v0__fillcap_32
XFILLER_31_16 VDD VDD VSS VSS gf180mcu_fd_sc_mcu7t5v0__fillcap_4
XFILLER_119_232 VDD VDD VSS VSS gf180mcu_fd_sc_mcu7t5v0__fill_1
X_1959_ _3986_/Q _3181_/A1 VDD VDD VSS VSS gf180mcu_fd_sc_mcu7t5v0__clkinv_1
XFILLER_107_416 VDD VDD VSS VSS gf180mcu_fd_sc_mcu7t5v0__fillcap_4
X_3629_ _4145_/Q _3723_/A2 _3629_/B1 _3667_/C2 _4196_/I _3629_/C2 _3630_/A2 VDD VDD
+ VSS VSS gf180mcu_fd_sc_mcu7t5v0__aoi222_1
Xoutput27 _4200_/Z pga_gain_control[2] VDD VDD VSS VSS gf180mcu_fd_sc_mcu7t5v0__dlyb_1
Xoutput16 _3936_/Q PAD_PU[0] VDD VDD VSS VSS gf180mcu_fd_sc_mcu7t5v0__dlyb_1
XFILLER_88_333 VDD VDD VSS VSS gf180mcu_fd_sc_mcu7t5v0__fill_2
XFILLER_29_422 VDD VDD VSS VSS gf180mcu_fd_sc_mcu7t5v0__fillcap_4
XFILLER_44_425 VDD VDD VSS VSS gf180mcu_fd_sc_mcu7t5v0__fill_1
XFILLER_72_45 VDD VDD VSS VSS gf180mcu_fd_sc_mcu7t5v0__fillcap_4
XFILLER_72_56 VDD VDD VSS VSS gf180mcu_fd_sc_mcu7t5v0__fillcap_16
XTAP_TAPCELL_ROW_14_339 VDD VSS gf180mcu_fd_sc_mcu7t5v0__filltie
XTAP_TAPCELL_ROW_22_383 VDD VSS gf180mcu_fd_sc_mcu7t5v0__filltie
XFILLER_113_419 VDD VDD VSS VSS gf180mcu_fd_sc_mcu7t5v0__fill_1
XFILLER_97_53 VDD VDD VSS VSS gf180mcu_fd_sc_mcu7t5v0__fill_2
XFILLER_97_86 VDD VDD VSS VSS gf180mcu_fd_sc_mcu7t5v0__fill_2
XTAP_TAPCELL_ROW_117_955 VDD VSS gf180mcu_fd_sc_mcu7t5v0__filltie
X_3980_ _3980_/D clkload1/I _3980_/Q VDD VDD VSS VSS gf180mcu_fd_sc_mcu7t5v0__dffq_1
Xmax_cap80 _3547_/B _3538_/B VDD VDD VSS VSS gf180mcu_fd_sc_mcu7t5v0__buf_4
X_2931_ _3838_/Q _3022_/A3 _2936_/A2 VDD VDD VSS VSS gf180mcu_fd_sc_mcu7t5v0__nor2_1
X_2862_ _2862_/I _2864_/B1 VDD VDD VSS VSS gf180mcu_fd_sc_mcu7t5v0__clkinv_1
Xclkbuf_1_0__f__1536_ clkbuf_0__1536_/Z _3548_/A2 VDD VDD VSS VSS gf180mcu_fd_sc_mcu7t5v0__clkbuf_16
XTAP_TAPCELL_ROW_100_855 VDD VSS gf180mcu_fd_sc_mcu7t5v0__filltie
X_2793_ _2760_/C _2795_/B _2793_/A3 _3899_/D VDD VDD VSS VSS gf180mcu_fd_sc_mcu7t5v0__nor3_1
X_3414_ _4070_/Q _4069_/Q _3410_/Z _3414_/Z VDD VDD VSS VSS gf180mcu_fd_sc_mcu7t5v0__and3_1
Xtop_level_103 trig_out_sl_control VDD VDD VSS VSS gf180mcu_fd_sc_mcu7t5v0__tiel
Xtop_level_114 trig_out_oe_control VDD VDD VSS VSS gf180mcu_fd_sc_mcu7t5v0__tieh
XPHY_EDGE_ROW_15_Right_15 VDD VSS gf180mcu_fd_sc_mcu7t5v0__endcap
X_3345_ _4055_/Q _4054_/Q _3339_/Z _3345_/Z VDD VDD VSS VSS gf180mcu_fd_sc_mcu7t5v0__and3_1
X_3276_ wire94/Z _3283_/A2 wire81/Z _3277_/B VDD VDD VSS VSS gf180mcu_fd_sc_mcu7t5v0__oai21_1
X_2227_ _4095_/Q _2248_/A2 _2229_/A1 VDD VDD VSS VSS gf180mcu_fd_sc_mcu7t5v0__nor2_1
XFILLER_97_196 VDD VDD VSS VSS gf180mcu_fd_sc_mcu7t5v0__fill_2
XTAP_TAPCELL_ROW_108_900 VDD VSS gf180mcu_fd_sc_mcu7t5v0__filltie
XFILLER_26_425 VDD VDD VSS VSS gf180mcu_fd_sc_mcu7t5v0__fill_1
X_2158_ _4054_/Q _2242_/A2 _2160_/A1 VDD VDD VSS VSS gf180mcu_fd_sc_mcu7t5v0__nor2_1
XPHY_EDGE_ROW_24_Right_24 VDD VSS gf180mcu_fd_sc_mcu7t5v0__endcap
X_2089_ _4147_/Q _3744_/A1 _2091_/A2 VDD VDD VSS VSS gf180mcu_fd_sc_mcu7t5v0__nor2_1
XFILLER_41_417 VDD VDD VSS VSS gf180mcu_fd_sc_mcu7t5v0__fill_2
XFILLER_53_288 VDD VDD VSS VSS gf180mcu_fd_sc_mcu7t5v0__fill_1
XFILLER_42_37 VDD VDD VSS VSS gf180mcu_fd_sc_mcu7t5v0__fillcap_4
XFILLER_107_246 VDD VDD VSS VSS gf180mcu_fd_sc_mcu7t5v0__fillcap_8
XPHY_EDGE_ROW_33_Right_33 VDD VSS gf180mcu_fd_sc_mcu7t5v0__endcap
XFILLER_88_130 VDD VDD VSS VSS gf180mcu_fd_sc_mcu7t5v0__fill_2
XFILLER_88_141 VDD VDD VSS VSS gf180mcu_fd_sc_mcu7t5v0__fill_1
XFILLER_88_185 VDD VDD VSS VSS gf180mcu_fd_sc_mcu7t5v0__fillcap_8
XFILLER_88_163 VDD VDD VSS VSS gf180mcu_fd_sc_mcu7t5v0__fillcap_4
XPHY_EDGE_ROW_42_Right_42 VDD VSS gf180mcu_fd_sc_mcu7t5v0__endcap
XTAP_TAPCELL_ROW_114_936 VDD VSS gf180mcu_fd_sc_mcu7t5v0__filltie
XPHY_EDGE_ROW_103_Left_225 VDD VSS gf180mcu_fd_sc_mcu7t5v0__endcap
XFILLER_32_417 VDD VDD VSS VSS gf180mcu_fd_sc_mcu7t5v0__fillcap_8
XFILLER_12_174 VDD VDD VSS VSS gf180mcu_fd_sc_mcu7t5v0__fill_1
XFILLER_32_81 VDD VDD VSS VSS gf180mcu_fd_sc_mcu7t5v0__fill_2
XPHY_EDGE_ROW_51_Right_51 VDD VSS gf180mcu_fd_sc_mcu7t5v0__endcap
XPHY_EDGE_ROW_112_Left_234 VDD VSS gf180mcu_fd_sc_mcu7t5v0__endcap
XFILLER_79_152 VDD VDD VSS VSS gf180mcu_fd_sc_mcu7t5v0__fillcap_8
X_3130_ _3130_/A1 _3138_/A2 _3130_/B _3962_/D VDD VDD VSS VSS gf180mcu_fd_sc_mcu7t5v0__aoi21_1
XFILLER_121_293 VDD VDD VSS VSS gf180mcu_fd_sc_mcu7t5v0__fillcap_8
XFILLER_79_196 VDD VDD VSS VSS gf180mcu_fd_sc_mcu7t5v0__fillcap_8
XPHY_EDGE_ROW_60_Right_60 VDD VSS gf180mcu_fd_sc_mcu7t5v0__endcap
X_3061_ _3286_/A1 _3082_/A2 wire81/Z _3062_/B VDD VDD VSS VSS gf180mcu_fd_sc_mcu7t5v0__oai21_1
XFILLER_82_317 VDD VDD VSS VSS gf180mcu_fd_sc_mcu7t5v0__fill_1
XTAP_TAPCELL_ROW_93_813 VDD VSS gf180mcu_fd_sc_mcu7t5v0__filltie
XPHY_EDGE_ROW_121_Left_243 VDD VSS gf180mcu_fd_sc_mcu7t5v0__endcap
X_2012_ _3933_/Q _3068_/A1 VDD VDD VSS VSS gf180mcu_fd_sc_mcu7t5v0__clkinv_1
XFILLER_35_266 VDD VDD VSS VSS gf180mcu_fd_sc_mcu7t5v0__fillcap_4
XFILLER_90_372 VDD VDD VSS VSS gf180mcu_fd_sc_mcu7t5v0__fillcap_4
XFILLER_90_361 VDD VDD VSS VSS gf180mcu_fd_sc_mcu7t5v0__fill_2
XFILLER_50_247 VDD VDD VSS VSS gf180mcu_fd_sc_mcu7t5v0__fillcap_16
X_3963_ _3963_/D _4155_/CLK _3963_/Q VDD VDD VSS VSS gf180mcu_fd_sc_mcu7t5v0__dffq_1
X_3894_ _3894_/D clkload9/I _3894_/Q VDD VDD VSS VSS gf180mcu_fd_sc_mcu7t5v0__dffq_1
X_2914_ _2760_/C _2914_/A2 _3915_/D VDD VDD VSS VSS gf180mcu_fd_sc_mcu7t5v0__nor2_1
X_2845_ _3964_/Q _2845_/A2 _2845_/A3 _2845_/Z VDD VDD VSS VSS gf180mcu_fd_sc_mcu7t5v0__xor3_1
X_2776_ _3111_/A1 _2776_/A2 _2776_/B _2805_/A2 VDD VDD VSS VSS gf180mcu_fd_sc_mcu7t5v0__oai21_1
Xhold134 _3925_/Q hold134/Z VDD VDD VSS VSS gf180mcu_fd_sc_mcu7t5v0__dlyc_1
Xhold123 _4169_/Q _4167_/D VDD VDD VSS VSS gf180mcu_fd_sc_mcu7t5v0__dlyc_1
XPHY_EDGE_ROW_103_Right_103 VDD VSS gf180mcu_fd_sc_mcu7t5v0__endcap
Xhold145 _3939_/Q _2006_/I VDD VDD VSS VSS gf180mcu_fd_sc_mcu7t5v0__dlyc_1
Xhold156 _3918_/Q hold156/Z VDD VDD VSS VSS gf180mcu_fd_sc_mcu7t5v0__dlyc_1
Xhold167 _3758_/Q hold167/Z VDD VDD VSS VSS gf180mcu_fd_sc_mcu7t5v0__dlyc_1
XFILLER_104_238 VDD VDD VSS VSS gf180mcu_fd_sc_mcu7t5v0__fill_2
Xhold189 _4003_/Q _1942_/I VDD VDD VSS VSS gf180mcu_fd_sc_mcu7t5v0__dlyc_1
Xhold178 _4025_/Q _1920_/I VDD VDD VSS VSS gf180mcu_fd_sc_mcu7t5v0__dlyc_1
X_3328_ _3395_/A1 _3328_/A2 _3327_/Z _4049_/D VDD VDD VSS VSS gf180mcu_fd_sc_mcu7t5v0__nor3_1
XFILLER_100_422 VDD VDD VSS VSS gf180mcu_fd_sc_mcu7t5v0__fillcap_4
X_3259_ wire94/Z _3274_/A2 wire81/Z _3260_/B VDD VDD VSS VSS gf180mcu_fd_sc_mcu7t5v0__oai21_1
XFILLER_37_59 VDD VDD VSS VSS gf180mcu_fd_sc_mcu7t5v0__fill_1
XFILLER_81_372 VDD VDD VSS VSS gf180mcu_fd_sc_mcu7t5v0__fill_2
XTAP_TAPCELL_ROW_111_917 VDD VSS gf180mcu_fd_sc_mcu7t5v0__filltie
XFILLER_78_22 VDD VDD VSS VSS gf180mcu_fd_sc_mcu7t5v0__fill_2
XFILLER_118_95 VDD VDD VSS VSS gf180mcu_fd_sc_mcu7t5v0__fill_1
XFILLER_78_66 VDD VDD VSS VSS gf180mcu_fd_sc_mcu7t5v0__fillcap_16
XFILLER_76_133 VDD VDD VSS VSS gf180mcu_fd_sc_mcu7t5v0__fill_1
XFILLER_94_43 VDD VDD VSS VSS gf180mcu_fd_sc_mcu7t5v0__fillcap_4
XTAP_TAPCELL_ROW_47_537 VDD VSS gf180mcu_fd_sc_mcu7t5v0__filltie
XFILLER_76_177 VDD VDD VSS VSS gf180mcu_fd_sc_mcu7t5v0__fillcap_4
XFILLER_91_114 VDD VDD VSS VSS gf180mcu_fd_sc_mcu7t5v0__fillcap_4
XFILLER_91_125 VDD VDD VSS VSS gf180mcu_fd_sc_mcu7t5v0__fillcap_8
XFILLER_32_247 VDD VDD VSS VSS gf180mcu_fd_sc_mcu7t5v0__fillcap_8
XTAP_TAPCELL_ROW_55_581 VDD VSS gf180mcu_fd_sc_mcu7t5v0__filltie
XFILLER_43_80 VDD VDD VSS VSS gf180mcu_fd_sc_mcu7t5v0__fill_1
X_2630_ _4010_/Q _2716_/A2 _2630_/B1 _2630_/B2 _2714_/A2 _4009_/Q _2631_/B2 VDD VDD
+ VSS VSS gf180mcu_fd_sc_mcu7t5v0__oai222_1
XFILLER_71_6 VDD VDD VSS VSS gf180mcu_fd_sc_mcu7t5v0__fillcap_16
X_2561_ _3995_/Q _2844_/A2 _2687_/A2 _3994_/Q _2561_/C _2602_/A2 VDD VDD VSS VSS gf180mcu_fd_sc_mcu7t5v0__aoi221_1
X_2492_ _4120_/Q _3923_/Q _2496_/B _2493_/A2 VDD VDD VSS VSS gf180mcu_fd_sc_mcu7t5v0__oai21_1
XFILLER_99_247 VDD VDD VSS VSS gf180mcu_fd_sc_mcu7t5v0__fillcap_8
X_4162_ input5/Z _4162_/CLK _4162_/Q VDD VDD VSS VSS gf180mcu_fd_sc_mcu7t5v0__dffq_1
X_4093_ _4093_/D clkload5/I _4093_/Q VDD VDD VSS VSS gf180mcu_fd_sc_mcu7t5v0__dffq_1
X_3113_ _3113_/A1 _3121_/A2 _3113_/B _3954_/D VDD VDD VSS VSS gf180mcu_fd_sc_mcu7t5v0__aoi21_1
X_3044_ _4024_/Q _3044_/A2 _3044_/B _3044_/C _3045_/A3 VDD VDD VSS VSS gf180mcu_fd_sc_mcu7t5v0__aoi211_1
X_3946_ _3946_/D _4162_/CLK _3946_/Q VDD VDD VSS VSS gf180mcu_fd_sc_mcu7t5v0__dffq_1
X_3877_ _3877_/D clkload7/I _3877_/Q VDD VDD VSS VSS gf180mcu_fd_sc_mcu7t5v0__dffq_1
X_2828_ _3128_/A1 _2687_/B _2828_/B _2829_/A2 VDD VDD VSS VSS gf180mcu_fd_sc_mcu7t5v0__oai21_1
XFILLER_117_352 VDD VDD VSS VSS gf180mcu_fd_sc_mcu7t5v0__fillcap_4
X_2759_ _2755_/Z _2759_/A2 _2763_/B _2760_/B VDD VDD VSS VSS gf180mcu_fd_sc_mcu7t5v0__oai21_1
XFILLER_58_177 VDD VDD VSS VSS gf180mcu_fd_sc_mcu7t5v0__fill_1
XTAP_TAPCELL_ROW_44_518 VDD VSS gf180mcu_fd_sc_mcu7t5v0__filltie
XFILLER_14_225 VDD VDD VSS VSS gf180mcu_fd_sc_mcu7t5v0__fillcap_4
XFILLER_54_383 VDD VDD VSS VSS gf180mcu_fd_sc_mcu7t5v0__fill_2
XTAP_TAPCELL_ROW_52_562 VDD VSS gf180mcu_fd_sc_mcu7t5v0__filltie
XFILLER_22_280 VDD VDD VSS VSS gf180mcu_fd_sc_mcu7t5v0__fill_1
XFILLER_80_89 VDD VDD VSS VSS gf180mcu_fd_sc_mcu7t5v0__fillcap_4
XFILLER_13_72 VDD VDD VSS VSS gf180mcu_fd_sc_mcu7t5v0__fillcap_64
XFILLER_89_43 VDD VDD VSS VSS gf180mcu_fd_sc_mcu7t5v0__fillcap_4
XFILLER_89_87 VDD VDD VSS VSS gf180mcu_fd_sc_mcu7t5v0__fillcap_4
XFILLER_1_195 VDD VDD VSS VSS gf180mcu_fd_sc_mcu7t5v0__fillcap_8
XFILLER_1_162 VDD VDD VSS VSS gf180mcu_fd_sc_mcu7t5v0__fillcap_16
XFILLER_49_155 VDD VDD VSS VSS gf180mcu_fd_sc_mcu7t5v0__fillcap_8
XFILLER_37_317 VDD VDD VSS VSS gf180mcu_fd_sc_mcu7t5v0__fill_1
XFILLER_49_199 VDD VDD VSS VSS gf180mcu_fd_sc_mcu7t5v0__fill_2
XFILLER_64_147 VDD VDD VSS VSS gf180mcu_fd_sc_mcu7t5v0__fillcap_8
X_3800_ _3800_/D clkload3/I _3800_/Q VDD VDD VSS VSS gf180mcu_fd_sc_mcu7t5v0__dffq_1
XFILLER_20_239 VDD VDD VSS VSS gf180mcu_fd_sc_mcu7t5v0__fill_1
X_1992_ _3953_/Q _3111_/A1 VDD VDD VSS VSS gf180mcu_fd_sc_mcu7t5v0__clkinv_1
X_3731_ _3756_/A1 _3725_/Z _3732_/B1 _3557_/B _3731_/C _4141_/D VDD VDD VSS VSS gf180mcu_fd_sc_mcu7t5v0__aoi221_1
XFILLER_13_291 VDD VDD VSS VSS gf180mcu_fd_sc_mcu7t5v0__fill_2
Xclkload10 _4162_/CLK clkload10/ZN VDD VDD VSS VSS gf180mcu_fd_sc_mcu7t5v0__inv_3
X_3662_ _3765_/Q _3662_/A2 _3662_/B1 _3781_/Q _3665_/A1 VDD VDD VSS VSS gf180mcu_fd_sc_mcu7t5v0__aoi22_1
Xclkload32 _3528_/A3 clkload32/Z VDD VDD VSS VSS gf180mcu_fd_sc_mcu7t5v0__clkbuf_2
Xclkload21 _4142_/CLK clkload21/ZN VDD VDD VSS VSS gf180mcu_fd_sc_mcu7t5v0__inv_3
X_3593_ _3782_/Q _3663_/A2 _3663_/B1 _3766_/Q _3596_/A1 VDD VDD VSS VSS gf180mcu_fd_sc_mcu7t5v0__aoi22_1
X_2613_ _4002_/Q _2887_/A2 _2896_/A2 _4001_/Q _2621_/A1 VDD VDD VSS VSS gf180mcu_fd_sc_mcu7t5v0__aoi22_1
X_2544_ _2548_/B1 _2544_/A2 _3877_/D VDD VDD VSS VSS gf180mcu_fd_sc_mcu7t5v0__nor2_1
X_2475_ _3809_/Q _2475_/A2 _2495_/B1 _3857_/Q _2495_/C _2477_/A1 VDD VDD VSS VSS gf180mcu_fd_sc_mcu7t5v0__oai221_1
X_4145_ _4145_/D _4164_/CLK _4145_/Q VDD VDD VSS VSS gf180mcu_fd_sc_mcu7t5v0__dffq_1
XFILLER_28_328 VDD VDD VSS VSS gf180mcu_fd_sc_mcu7t5v0__fill_1
XFILLER_28_317 VDD VDD VSS VSS gf180mcu_fd_sc_mcu7t5v0__fillcap_4
X_4076_ _4076_/D _4079_/CLK _4076_/Q VDD VDD VSS VSS gf180mcu_fd_sc_mcu7t5v0__dffq_1
XFILLER_55_136 VDD VDD VSS VSS gf180mcu_fd_sc_mcu7t5v0__fillcap_4
X_3027_ _4007_/Q _3224_/A1 _3156_/A1 _3975_/Q _3027_/C1 _4031_/Q _3030_/A2 VDD VDD
+ VSS VSS gf180mcu_fd_sc_mcu7t5v0__aoi222_1
Xclkload4 clkload4/I clkload4/ZN VDD VDD VSS VSS gf180mcu_fd_sc_mcu7t5v0__clkinv_4
X_3929_ _3929_/D _4170_/CLK _3929_/Q VDD VDD VSS VSS gf180mcu_fd_sc_mcu7t5v0__dffq_1
XFILLER_50_37 VDD VDD VSS VSS gf180mcu_fd_sc_mcu7t5v0__fillcap_4
XFILLER_3_416 VDD VDD VSS VSS gf180mcu_fd_sc_mcu7t5v0__fillcap_4
XFILLER_117_193 VDD VDD VSS VSS gf180mcu_fd_sc_mcu7t5v0__fillcap_8
XFILLER_105_377 VDD VDD VSS VSS gf180mcu_fd_sc_mcu7t5v0__fillcap_8
XFILLER_120_325 VDD VDD VSS VSS gf180mcu_fd_sc_mcu7t5v0__fillcap_4
XFILLER_120_358 VDD VDD VSS VSS gf180mcu_fd_sc_mcu7t5v0__fillcap_16
XTAP_TAPCELL_ROW_6_287 VDD VSS gf180mcu_fd_sc_mcu7t5v0__filltie
XFILLER_6_232 VDD VDD VSS VSS gf180mcu_fd_sc_mcu7t5v0__fillcap_4
XFILLER_40_92 VDD VDD VSS VSS gf180mcu_fd_sc_mcu7t5v0__fill_1
X_2260_ _3836_/Q _4161_/Q _2260_/Z VDD VDD VSS VSS gf180mcu_fd_sc_mcu7t5v0__and2_1
XFILLER_111_358 VDD VDD VSS VSS gf180mcu_fd_sc_mcu7t5v0__fillcap_4
X_2191_ _4082_/Q _2242_/A2 _2193_/A1 VDD VDD VSS VSS gf180mcu_fd_sc_mcu7t5v0__nor2_1
XFILLER_1_64 VDD VDD VSS VSS gf180mcu_fd_sc_mcu7t5v0__fillcap_4
XFILLER_37_136 VDD VDD VSS VSS gf180mcu_fd_sc_mcu7t5v0__fillcap_4
X_1975_ _3970_/Q _3147_/A1 VDD VDD VSS VSS gf180mcu_fd_sc_mcu7t5v0__clkinv_1
X_3714_ _3714_/A1 _3714_/A2 _4137_/D VDD VDD VSS VSS gf180mcu_fd_sc_mcu7t5v0__nor2_1
XFILLER_20_29 VDD VDD VSS VSS gf180mcu_fd_sc_mcu7t5v0__fillcap_4
X_3645_ _3645_/A1 _3645_/A2 _3645_/A3 _3646_/A2 VDD VDD VSS VSS gf180mcu_fd_sc_mcu7t5v0__nand3_1
XFILLER_106_119 VDD VDD VSS VSS gf180mcu_fd_sc_mcu7t5v0__fillcap_16
X_3576_ _4111_/Q _4110_/Q _4109_/Q _3564_/Z _3583_/A1 VDD VDD VSS VSS gf180mcu_fd_sc_mcu7t5v0__nand4_1
X_2527_ _2527_/A1 _2527_/A2 _3873_/D VDD VDD VSS VSS gf180mcu_fd_sc_mcu7t5v0__nand2_1
X_2458_ _2428_/B _2427_/Z _2462_/B VDD VDD VSS VSS gf180mcu_fd_sc_mcu7t5v0__nand2_1
XFILLER_29_49 VDD VDD VSS VSS gf180mcu_fd_sc_mcu7t5v0__fillcap_16
XPHY_EDGE_ROW_89_Right_89 VDD VSS gf180mcu_fd_sc_mcu7t5v0__endcap
XFILLER_28_103 VDD VDD VSS VSS gf180mcu_fd_sc_mcu7t5v0__fill_2
X_2389_ _2389_/I _3838_/D VDD VDD VSS VSS gf180mcu_fd_sc_mcu7t5v0__clkinv_1
XTAP_TAPCELL_ROW_3_268 VDD VSS gf180mcu_fd_sc_mcu7t5v0__filltie
X_4128_ _4128_/D _4164_/CLK _4128_/Q VDD VDD VSS VSS gf180mcu_fd_sc_mcu7t5v0__dffq_1
XFILLER_28_169 VDD VDD VSS VSS gf180mcu_fd_sc_mcu7t5v0__fillcap_4
X_4059_ _4059_/D _4104_/CLK _4059_/Q VDD VDD VSS VSS gf180mcu_fd_sc_mcu7t5v0__dffq_1
XFILLER_43_139 VDD VDD VSS VSS gf180mcu_fd_sc_mcu7t5v0__fill_1
XPHY_EDGE_ROW_98_Right_98 VDD VSS gf180mcu_fd_sc_mcu7t5v0__endcap
XFILLER_101_54 VDD VDD VSS VSS gf180mcu_fd_sc_mcu7t5v0__fill_2
XFILLER_101_76 VDD VDD VSS VSS gf180mcu_fd_sc_mcu7t5v0__fill_1
XFILLER_120_100 VDD VDD VSS VSS gf180mcu_fd_sc_mcu7t5v0__fillcap_4
XFILLER_120_177 VDD VDD VSS VSS gf180mcu_fd_sc_mcu7t5v0__fillcap_8
XTAP_TAPCELL_ROW_77_716 VDD VSS gf180mcu_fd_sc_mcu7t5v0__filltie
XFILLER_19_60 VDD VDD VSS VSS gf180mcu_fd_sc_mcu7t5v0__fill_1
XTAP_TAPCELL_ROW_85_760 VDD VSS gf180mcu_fd_sc_mcu7t5v0__filltie
XFILLER_34_117 VDD VDD VSS VSS gf180mcu_fd_sc_mcu7t5v0__fill_2
XFILLER_74_286 VDD VDD VSS VSS gf180mcu_fd_sc_mcu7t5v0__fill_2
XFILLER_51_80 VDD VDD VSS VSS gf180mcu_fd_sc_mcu7t5v0__fillcap_4
X_3430_ _4076_/Q _3428_/Z _3430_/Z VDD VDD VSS VSS gf180mcu_fd_sc_mcu7t5v0__and2_1
X_3361_ _3363_/B _3361_/A2 _3360_/Z _4060_/D VDD VDD VSS VSS gf180mcu_fd_sc_mcu7t5v0__nor3_1
X_2312_ _2277_/B _2331_/C _2317_/A2 VDD VDD VSS VSS gf180mcu_fd_sc_mcu7t5v0__nor2_1
X_3292_ _4140_/Q _3731_/C _3547_/B VDD VDD VSS VSS gf180mcu_fd_sc_mcu7t5v0__nor2_1
XFILLER_57_209 VDD VDD VSS VSS gf180mcu_fd_sc_mcu7t5v0__fill_1
X_2243_ _3803_/Q _2243_/A2 _3746_/B _2244_/A2 VDD VDD VSS VSS gf180mcu_fd_sc_mcu7t5v0__oai21_1
XFILLER_38_423 VDD VDD VSS VSS gf180mcu_fd_sc_mcu7t5v0__fill_2
X_2174_ hold209/Z _2243_/A2 _3746_/B _2175_/A2 VDD VDD VSS VSS gf180mcu_fd_sc_mcu7t5v0__oai21_1
XTAP_TAPCELL_ROW_0_249 VDD VSS gf180mcu_fd_sc_mcu7t5v0__filltie
XFILLER_15_18 VDD VDD VSS VSS gf180mcu_fd_sc_mcu7t5v0__fill_1
XTAP_TAPCELL_ROW_91_796 VDD VSS gf180mcu_fd_sc_mcu7t5v0__filltie
X_1958_ _3987_/Q _3183_/A1 VDD VDD VSS VSS gf180mcu_fd_sc_mcu7t5v0__clkinv_1
X_1889_ _1889_/I _3578_/A1 VDD VDD VSS VSS gf180mcu_fd_sc_mcu7t5v0__clkinv_1
X_3628_ _4135_/Q _3700_/A1 _3679_/A1 _4127_/Q _3630_/A1 VDD VDD VSS VSS gf180mcu_fd_sc_mcu7t5v0__aoi22_1
Xoutput17 _3935_/Q PAD_PU[1] VDD VDD VSS VSS gf180mcu_fd_sc_mcu7t5v0__dlyb_1
Xoutput28 _4106_/Q trigger_signal_out VDD VDD VSS VSS gf180mcu_fd_sc_mcu7t5v0__dlyb_1
X_3559_ _3579_/B _3566_/B _4106_/D VDD VDD VSS VSS gf180mcu_fd_sc_mcu7t5v0__nor2_1
XFILLER_102_111 VDD VDD VSS VSS gf180mcu_fd_sc_mcu7t5v0__fill_2
XFILLER_56_242 VDD VDD VSS VSS gf180mcu_fd_sc_mcu7t5v0__fill_2
XFILLER_112_31 VDD VDD VSS VSS gf180mcu_fd_sc_mcu7t5v0__fillcap_4
XTAP_TAPCELL_ROW_39_484 VDD VSS gf180mcu_fd_sc_mcu7t5v0__filltie
XFILLER_71_201 VDD VDD VSS VSS gf180mcu_fd_sc_mcu7t5v0__fill_2
XFILLER_24_172 VDD VDD VSS VSS gf180mcu_fd_sc_mcu7t5v0__fill_2
XFILLER_12_323 VDD VDD VSS VSS gf180mcu_fd_sc_mcu7t5v0__fill_1
XPHY_EDGE_ROW_117_Right_117 VDD VSS gf180mcu_fd_sc_mcu7t5v0__endcap
XTAP_TAPCELL_ROW_22_384 VDD VSS gf180mcu_fd_sc_mcu7t5v0__filltie
XFILLER_21_72 VDD VDD VSS VSS gf180mcu_fd_sc_mcu7t5v0__fillcap_32
XFILLER_113_409 VDD VDD VSS VSS gf180mcu_fd_sc_mcu7t5v0__fillcap_8
XFILLER_97_10 VDD VDD VSS VSS gf180mcu_fd_sc_mcu7t5v0__fill_1
XFILLER_98_109 VDD VDD VSS VSS gf180mcu_fd_sc_mcu7t5v0__fill_1
XFILLER_79_312 VDD VDD VSS VSS gf180mcu_fd_sc_mcu7t5v0__fill_2
XFILLER_97_43 VDD VDD VSS VSS gf180mcu_fd_sc_mcu7t5v0__fillcap_4
XFILLER_39_209 VDD VDD VSS VSS gf180mcu_fd_sc_mcu7t5v0__fill_1
XTAP_TAPCELL_ROW_117_956 VDD VSS gf180mcu_fd_sc_mcu7t5v0__filltie
XFILLER_47_242 VDD VDD VSS VSS gf180mcu_fd_sc_mcu7t5v0__fillcap_4
Xmax_cap70 _2557_/A2 _2396_/A2 VDD VDD VSS VSS gf180mcu_fd_sc_mcu7t5v0__clkbuf_2
X_2930_ _3840_/Q _2930_/A2 wire79/Z _3022_/A3 VDD VDD VSS VSS gf180mcu_fd_sc_mcu7t5v0__nand3_1
Xmax_cap92 _3849_/Q _3751_/I1 VDD VDD VSS VSS gf180mcu_fd_sc_mcu7t5v0__buf_4
X_2861_ _2848_/Z _2857_/Z _2862_/I VDD VDD VSS VSS gf180mcu_fd_sc_mcu7t5v0__nand2_1
X_2792_ _2792_/A1 _2792_/A2 _2793_/A3 VDD VDD VSS VSS gf180mcu_fd_sc_mcu7t5v0__nor2_1
XFILLER_116_247 VDD VDD VSS VSS gf180mcu_fd_sc_mcu7t5v0__fill_1
X_3413_ _4069_/Q _3410_/Z _3413_/B _4069_/D VDD VDD VSS VSS gf180mcu_fd_sc_mcu7t5v0__aoi21_1
Xtop_level_115 trig_out_pd_control VDD VDD VSS VSS gf180mcu_fd_sc_mcu7t5v0__tieh
Xtop_level_104 PAD_PDRV0[0] VDD VDD VSS VSS gf180mcu_fd_sc_mcu7t5v0__tieh
XFILLER_97_142 VDD VDD VSS VSS gf180mcu_fd_sc_mcu7t5v0__fillcap_8
X_3344_ _4055_/Q _3342_/Z _3346_/A2 VDD VDD VSS VSS gf180mcu_fd_sc_mcu7t5v0__nor2_1
X_3275_ _3275_/A1 _3275_/A2 _3283_/A2 VDD VDD VSS VSS gf180mcu_fd_sc_mcu7t5v0__nand2_1
XFILLER_97_164 VDD VDD VSS VSS gf180mcu_fd_sc_mcu7t5v0__fillcap_32
X_2226_ _3523_/A1 _2111_/Z _2226_/B _3796_/D VDD VDD VSS VSS gf180mcu_fd_sc_mcu7t5v0__aoi21_1
XTAP_TAPCELL_ROW_108_901 VDD VSS gf180mcu_fd_sc_mcu7t5v0__filltie
XFILLER_53_212 VDD VDD VSS VSS gf180mcu_fd_sc_mcu7t5v0__fillcap_8
X_2157_ _2157_/A1 _2157_/A2 _3772_/D VDD VDD VSS VSS gf180mcu_fd_sc_mcu7t5v0__nor2_1
X_2088_ _4147_/Q _4146_/Q _3723_/B VDD VDD VSS VSS gf180mcu_fd_sc_mcu7t5v0__nor2_1
XFILLER_21_120 VDD VDD VSS VSS gf180mcu_fd_sc_mcu7t5v0__fill_1
XFILLER_21_197 VDD VDD VSS VSS gf180mcu_fd_sc_mcu7t5v0__fill_1
XFILLER_107_31 VDD VDD VSS VSS gf180mcu_fd_sc_mcu7t5v0__fillcap_16
XFILLER_67_35 VDD VDD VSS VSS gf180mcu_fd_sc_mcu7t5v0__fill_2
XFILLER_107_86 VDD VDD VSS VSS gf180mcu_fd_sc_mcu7t5v0__fill_2
XTAP_TAPCELL_ROW_114_937 VDD VSS gf180mcu_fd_sc_mcu7t5v0__filltie
XFILLER_12_131 VDD VDD VSS VSS gf180mcu_fd_sc_mcu7t5v0__fill_1
XFILLER_12_186 VDD VDD VSS VSS gf180mcu_fd_sc_mcu7t5v0__fill_1
XFILLER_8_113 VDD VDD VSS VSS gf180mcu_fd_sc_mcu7t5v0__fill_1
XTAP_TAPCELL_ROW_10_310 VDD VSS gf180mcu_fd_sc_mcu7t5v0__filltie
XFILLER_113_228 VDD VDD VSS VSS gf180mcu_fd_sc_mcu7t5v0__fill_2
XFILLER_79_142 VDD VDD VSS VSS gf180mcu_fd_sc_mcu7t5v0__fill_1
XFILLER_79_164 VDD VDD VSS VSS gf180mcu_fd_sc_mcu7t5v0__fill_2
X_3060_ _3060_/A1 _3275_/A2 _3082_/A2 VDD VDD VSS VSS gf180mcu_fd_sc_mcu7t5v0__nand2_1
X_2011_ _3934_/Q _3070_/A1 VDD VDD VSS VSS gf180mcu_fd_sc_mcu7t5v0__clkinv_1
XFILLER_35_212 VDD VDD VSS VSS gf180mcu_fd_sc_mcu7t5v0__fill_2
XFILLER_35_201 VDD VDD VSS VSS gf180mcu_fd_sc_mcu7t5v0__fill_1
XFILLER_57_90 VDD VDD VSS VSS gf180mcu_fd_sc_mcu7t5v0__fillcap_16
XFILLER_35_256 VDD VDD VSS VSS gf180mcu_fd_sc_mcu7t5v0__fillcap_4
X_3962_ _3962_/D _4155_/CLK _3962_/Q VDD VDD VSS VSS gf180mcu_fd_sc_mcu7t5v0__dffq_1
X_3893_ _3893_/D _4162_/CLK _3893_/Q VDD VDD VSS VSS gf180mcu_fd_sc_mcu7t5v0__dffq_1
X_2913_ _2920_/A2 _2912_/Z _2914_/A2 VDD VDD VSS VSS gf180mcu_fd_sc_mcu7t5v0__nand2_1
X_2844_ _3132_/A1 _2844_/A2 _2844_/B _2845_/A3 VDD VDD VSS VSS gf180mcu_fd_sc_mcu7t5v0__oai21_1
X_2775_ _3955_/Q _3897_/Q _2798_/A1 VDD VDD VSS VSS gf180mcu_fd_sc_mcu7t5v0__xnor2_1
Xhold124 _3835_/Q hold124/Z VDD VDD VSS VSS gf180mcu_fd_sc_mcu7t5v0__dlyc_1
Xhold135 _4143_/Q hold135/Z VDD VDD VSS VSS gf180mcu_fd_sc_mcu7t5v0__dlyc_1
Xhold146 _4111_/Q _1889_/I VDD VDD VSS VSS gf180mcu_fd_sc_mcu7t5v0__dlyc_1
Xhold157 _3977_/Q _1968_/I VDD VDD VSS VSS gf180mcu_fd_sc_mcu7t5v0__dlyc_1
Xhold168 hold168/I _3758_/D VDD VDD VSS VSS gf180mcu_fd_sc_mcu7t5v0__dlyc_1
Xhold179 _4055_/Q hold179/Z VDD VDD VSS VSS gf180mcu_fd_sc_mcu7t5v0__dlyc_1
X_3327_ _4049_/Q _3324_/Z _3327_/Z VDD VDD VSS VSS gf180mcu_fd_sc_mcu7t5v0__and2_1
XFILLER_58_304 VDD VDD VSS VSS gf180mcu_fd_sc_mcu7t5v0__fill_1
XFILLER_85_101 VDD VDD VSS VSS gf180mcu_fd_sc_mcu7t5v0__fill_2
XFILLER_85_134 VDD VDD VSS VSS gf180mcu_fd_sc_mcu7t5v0__fillcap_4
X_3258_ _3258_/A1 _3275_/A2 _3268_/A2 VDD VDD VSS VSS gf180mcu_fd_sc_mcu7t5v0__nand2_1
X_2209_ _4088_/Q _2248_/A2 _2211_/A1 VDD VDD VSS VSS gf180mcu_fd_sc_mcu7t5v0__nor2_1
X_3189_ _3189_/A1 wire44/Z _3189_/B _3990_/D VDD VDD VSS VSS gf180mcu_fd_sc_mcu7t5v0__aoi21_1
XFILLER_85_178 VDD VDD VSS VSS gf180mcu_fd_sc_mcu7t5v0__fill_2
XFILLER_53_15 VDD VDD VSS VSS gf180mcu_fd_sc_mcu7t5v0__fillcap_8
XTAP_TAPCELL_ROW_111_918 VDD VSS gf180mcu_fd_sc_mcu7t5v0__filltie
Xclkbuf_regs_1_signal_clock _3459_/ZN clkbuf_0__1473__regs/I VDD VDD VSS VSS gf180mcu_fd_sc_mcu7t5v0__clkbuf_16
XFILLER_78_56 VDD VDD VSS VSS gf180mcu_fd_sc_mcu7t5v0__fill_2
XFILLER_91_137 VDD VDD VSS VSS gf180mcu_fd_sc_mcu7t5v0__fill_2
XFILLER_17_278 VDD VDD VSS VSS gf180mcu_fd_sc_mcu7t5v0__fill_2
XTAP_TAPCELL_ROW_55_582 VDD VSS gf180mcu_fd_sc_mcu7t5v0__filltie
XFILLER_9_422 VDD VDD VSS VSS gf180mcu_fd_sc_mcu7t5v0__fillcap_4
X_2560_ _3204_/A1 _3907_/Q _3906_/Q _3202_/A1 _2561_/C VDD VDD VSS VSS gf180mcu_fd_sc_mcu7t5v0__oai22_1
X_2491_ _3813_/Q _2495_/A2 _2495_/B1 _3861_/Q _2495_/C _2493_/A1 VDD VDD VSS VSS gf180mcu_fd_sc_mcu7t5v0__oai221_1
X_4161_ _4161_/D clkload9/I _4161_/Q VDD VDD VSS VSS gf180mcu_fd_sc_mcu7t5v0__dffq_1
XFILLER_101_209 VDD VDD VSS VSS gf180mcu_fd_sc_mcu7t5v0__fill_1
X_4092_ _4092_/D clkload5/I _4092_/Q VDD VDD VSS VSS gf180mcu_fd_sc_mcu7t5v0__dffq_1
X_3112_ wire91/I _3121_/A2 _3256_/B _3113_/B VDD VDD VSS VSS gf180mcu_fd_sc_mcu7t5v0__oai21_1
XFILLER_55_307 VDD VDD VSS VSS gf180mcu_fd_sc_mcu7t5v0__fill_1
X_3043_ _3043_/A1 _3043_/A2 _3043_/A3 _3043_/A4 _3044_/C VDD VDD VSS VSS gf180mcu_fd_sc_mcu7t5v0__nand4_1
XFILLER_82_126 VDD VDD VSS VSS gf180mcu_fd_sc_mcu7t5v0__fill_1
XFILLER_23_204 VDD VDD VSS VSS gf180mcu_fd_sc_mcu7t5v0__fill_1
XFILLER_90_181 VDD VDD VSS VSS gf180mcu_fd_sc_mcu7t5v0__fillcap_16
X_3945_ _3945_/D _4162_/CLK _3945_/Q VDD VDD VSS VSS gf180mcu_fd_sc_mcu7t5v0__dffq_1
XFILLER_23_248 VDD VDD VSS VSS gf180mcu_fd_sc_mcu7t5v0__fillcap_8
X_3876_ _3876_/D clkload7/I _3876_/Q VDD VDD VSS VSS gf180mcu_fd_sc_mcu7t5v0__dffq_1
X_2827_ _2827_/I _2833_/A2 VDD VDD VSS VSS gf180mcu_fd_sc_mcu7t5v0__clkinv_1
X_2758_ _3951_/Q _3893_/Q _2755_/Z _2763_/B VDD VDD VSS VSS gf180mcu_fd_sc_mcu7t5v0__nand3_1
X_2689_ _2677_/B _2689_/A2 _2689_/B _2692_/A1 VDD VDD VSS VSS gf180mcu_fd_sc_mcu7t5v0__oai21_1
XFILLER_58_123 VDD VDD VSS VSS gf180mcu_fd_sc_mcu7t5v0__fillcap_4
XFILLER_104_32 VDD VDD VSS VSS gf180mcu_fd_sc_mcu7t5v0__fill_2
XFILLER_73_137 VDD VDD VSS VSS gf180mcu_fd_sc_mcu7t5v0__fill_2
XTAP_TAPCELL_ROW_44_519 VDD VSS gf180mcu_fd_sc_mcu7t5v0__filltie
XFILLER_64_47 VDD VDD VSS VSS gf180mcu_fd_sc_mcu7t5v0__fillcap_16
XFILLER_120_75 VDD VDD VSS VSS gf180mcu_fd_sc_mcu7t5v0__fill_2
XTAP_TAPCELL_ROW_52_563 VDD VSS gf180mcu_fd_sc_mcu7t5v0__filltie
XFILLER_6_425 VDD VDD VSS VSS gf180mcu_fd_sc_mcu7t5v0__fill_1
XFILLER_108_353 VDD VDD VSS VSS gf180mcu_fd_sc_mcu7t5v0__fill_1
XPHY_EDGE_ROW_8_Left_130 VDD VSS gf180mcu_fd_sc_mcu7t5v0__endcap
XFILLER_89_292 VDD VDD VSS VSS gf180mcu_fd_sc_mcu7t5v0__fill_1
XFILLER_37_307 VDD VDD VSS VSS gf180mcu_fd_sc_mcu7t5v0__fillcap_8
XFILLER_38_70 VDD VDD VSS VSS gf180mcu_fd_sc_mcu7t5v0__fillcap_16
XFILLER_49_167 VDD VDD VSS VSS gf180mcu_fd_sc_mcu7t5v0__fill_2
XFILLER_64_104 VDD VDD VSS VSS gf180mcu_fd_sc_mcu7t5v0__fill_1
XFILLER_64_115 VDD VDD VSS VSS gf180mcu_fd_sc_mcu7t5v0__fillcap_32
XFILLER_64_159 VDD VDD VSS VSS gf180mcu_fd_sc_mcu7t5v0__fill_2
XFILLER_20_229 VDD VDD VSS VSS gf180mcu_fd_sc_mcu7t5v0__fillcap_8
X_1991_ _3954_/Q _3113_/A1 VDD VDD VSS VSS gf180mcu_fd_sc_mcu7t5v0__clkinv_1
X_3730_ _3730_/I _3732_/B1 VDD VDD VSS VSS gf180mcu_fd_sc_mcu7t5v0__clkinv_1
X_3661_ _3731_/C _3661_/A2 _4120_/D VDD VDD VSS VSS gf180mcu_fd_sc_mcu7t5v0__nor2_1
Xclkload11 _4017_/CLK clkload11/ZN VDD VDD VSS VSS gf180mcu_fd_sc_mcu7t5v0__clkinv_8
Xclkload33 _3527_/B clkload33/Z VDD VDD VSS VSS gf180mcu_fd_sc_mcu7t5v0__clkbuf_2
X_3592_ _3592_/A1 _3720_/A2 _3663_/B1 VDD VDD VSS VSS gf180mcu_fd_sc_mcu7t5v0__nor2_1
Xclkload22 _4164_/D clkload22/Z VDD VDD VSS VSS gf180mcu_fd_sc_mcu7t5v0__clkbuf_2
X_2612_ _3211_/A1 _3910_/Q _3909_/Q _3209_/A1 _2620_/A2 VDD VDD VSS VSS gf180mcu_fd_sc_mcu7t5v0__aoi22_1
X_2543_ _3813_/Q _2543_/A2 _2543_/B1 _3877_/Q _2544_/A2 VDD VDD VSS VSS gf180mcu_fd_sc_mcu7t5v0__oai22_1
X_2474_ _2474_/I0 hold203/Z _2489_/C _3864_/D VDD VDD VSS VSS gf180mcu_fd_sc_mcu7t5v0__mux2_2
XFILLER_68_421 VDD VDD VSS VSS gf180mcu_fd_sc_mcu7t5v0__fillcap_4
X_4144_ _4144_/D _4149_/CLK _4144_/Q VDD VDD VSS VSS gf180mcu_fd_sc_mcu7t5v0__dffq_1
X_4075_ _4075_/D _4079_/CLK _4075_/Q VDD VDD VSS VSS gf180mcu_fd_sc_mcu7t5v0__dffq_1
X_3026_ _3026_/I _3031_/B VDD VDD VSS VSS gf180mcu_fd_sc_mcu7t5v0__clkinv_1
XFILLER_36_384 VDD VDD VSS VSS gf180mcu_fd_sc_mcu7t5v0__fill_1
Xclkload5 clkload5/I clkload5/ZN VDD VDD VSS VSS gf180mcu_fd_sc_mcu7t5v0__clkinv_4
X_3928_ _3928_/D _4142_/CLK _3928_/Q VDD VDD VSS VSS gf180mcu_fd_sc_mcu7t5v0__dffq_1
XFILLER_109_128 VDD VDD VSS VSS gf180mcu_fd_sc_mcu7t5v0__fillcap_4
X_3859_ _3859_/D clkload7/I _3859_/Q VDD VDD VSS VSS gf180mcu_fd_sc_mcu7t5v0__dffq_1
XFILLER_50_49 VDD VDD VSS VSS gf180mcu_fd_sc_mcu7t5v0__fillcap_4
XFILLER_105_389 VDD VDD VSS VSS gf180mcu_fd_sc_mcu7t5v0__fill_2
XTAP_TAPCELL_ROW_6_288 VDD VSS gf180mcu_fd_sc_mcu7t5v0__filltie
XFILLER_74_424 VDD VDD VSS VSS gf180mcu_fd_sc_mcu7t5v0__fill_2
XFILLER_42_387 VDD VDD VSS VSS gf180mcu_fd_sc_mcu7t5v0__fillcap_4
XFILLER_10_273 VDD VDD VSS VSS gf180mcu_fd_sc_mcu7t5v0__fill_1
XFILLER_6_255 VDD VDD VSS VSS gf180mcu_fd_sc_mcu7t5v0__fill_2
XFILLER_111_337 VDD VDD VSS VSS gf180mcu_fd_sc_mcu7t5v0__fillcap_4
XFILLER_27_6 VDD VDD VSS VSS gf180mcu_fd_sc_mcu7t5v0__fillcap_4
X_2190_ _2190_/A1 _2190_/A2 _3783_/D VDD VDD VSS VSS gf180mcu_fd_sc_mcu7t5v0__nor2_1
XTAP_TAPCELL_ROW_88_780 VDD VSS gf180mcu_fd_sc_mcu7t5v0__filltie
XFILLER_52_107 VDD VDD VSS VSS gf180mcu_fd_sc_mcu7t5v0__fillcap_32
XFILLER_18_384 VDD VDD VSS VSS gf180mcu_fd_sc_mcu7t5v0__fill_1
XTAP_TAPCELL_ROW_71_680 VDD VSS gf180mcu_fd_sc_mcu7t5v0__filltie
X_1974_ _3971_/Q _3149_/A1 VDD VDD VSS VSS gf180mcu_fd_sc_mcu7t5v0__clkinv_1
X_3713_ _4137_/Q _3699_/Z wire81/Z _3714_/A2 VDD VDD VSS VSS gf180mcu_fd_sc_mcu7t5v0__oai21_1
X_3644_ _3795_/Q wire71/Z _3664_/B1 _3803_/Q _3645_/A3 VDD VDD VSS VSS gf180mcu_fd_sc_mcu7t5v0__aoi22_1
X_3575_ hold231/Z _4109_/Q _3582_/A2 _3564_/Z _3578_/A2 VDD VDD VSS VSS gf180mcu_fd_sc_mcu7t5v0__nand4_1
X_2526_ _3809_/Q _2548_/A2 _2526_/B _2527_/A2 VDD VDD VSS VSS gf180mcu_fd_sc_mcu7t5v0__aoi21_1
X_2457_ _2457_/A1 _2495_/A2 _2495_/B1 _2457_/B2 _2469_/A2 VDD VDD VSS VSS gf180mcu_fd_sc_mcu7t5v0__oai22_1
X_2388_ _3872_/Q _2396_/A2 _2400_/B1 _3838_/Q _2389_/I VDD VDD VSS VSS gf180mcu_fd_sc_mcu7t5v0__aoi22_1
XFILLER_28_115 VDD VDD VSS VSS gf180mcu_fd_sc_mcu7t5v0__fill_1
XTAP_TAPCELL_ROW_3_269 VDD VSS gf180mcu_fd_sc_mcu7t5v0__filltie
XFILLER_56_424 VDD VDD VSS VSS gf180mcu_fd_sc_mcu7t5v0__fill_2
X_4127_ _4127_/D _4164_/CLK _4127_/Q VDD VDD VSS VSS gf180mcu_fd_sc_mcu7t5v0__dffq_1
X_4058_ _4058_/D _4058_/CLK _4058_/Q VDD VDD VSS VSS gf180mcu_fd_sc_mcu7t5v0__dffq_1
X_3009_ hold142/Z _3018_/A2 _3018_/B1 _3009_/B2 _3010_/A2 VDD VDD VSS VSS gf180mcu_fd_sc_mcu7t5v0__aoi22_1
XFILLER_83_298 VDD VDD VSS VSS gf180mcu_fd_sc_mcu7t5v0__fill_2
XFILLER_101_22 VDD VDD VSS VSS gf180mcu_fd_sc_mcu7t5v0__fill_2
XFILLER_24_387 VDD VDD VSS VSS gf180mcu_fd_sc_mcu7t5v0__fillcap_32
XPHY_EDGE_ROW_89_Left_211 VDD VSS gf180mcu_fd_sc_mcu7t5v0__endcap
XFILLER_105_120 VDD VDD VSS VSS gf180mcu_fd_sc_mcu7t5v0__fillcap_16
XFILLER_105_142 VDD VDD VSS VSS gf180mcu_fd_sc_mcu7t5v0__fillcap_8
XFILLER_120_145 VDD VDD VSS VSS gf180mcu_fd_sc_mcu7t5v0__fill_1
XFILLER_120_123 VDD VDD VSS VSS gf180mcu_fd_sc_mcu7t5v0__fillcap_16
XFILLER_86_34 VDD VDD VSS VSS gf180mcu_fd_sc_mcu7t5v0__fill_1
XTAP_TAPCELL_ROW_77_717 VDD VSS gf180mcu_fd_sc_mcu7t5v0__filltie
XFILLER_19_137 VDD VDD VSS VSS gf180mcu_fd_sc_mcu7t5v0__fill_2
XFILLER_19_72 VDD VDD VSS VSS gf180mcu_fd_sc_mcu7t5v0__fill_2
XPHY_EDGE_ROW_98_Left_220 VDD VSS gf180mcu_fd_sc_mcu7t5v0__endcap
XFILLER_101_392 VDD VDD VSS VSS gf180mcu_fd_sc_mcu7t5v0__fill_1
XTAP_TAPCELL_ROW_85_761 VDD VSS gf180mcu_fd_sc_mcu7t5v0__filltie
XFILLER_34_107 VDD VDD VSS VSS gf180mcu_fd_sc_mcu7t5v0__fill_1
XFILLER_15_343 VDD VDD VSS VSS gf180mcu_fd_sc_mcu7t5v0__fillcap_4
X_3360_ _4060_/Q _4059_/Q _3354_/Z _3360_/Z VDD VDD VSS VSS gf180mcu_fd_sc_mcu7t5v0__and3_1
X_2311_ _4159_/Q _2252_/Z _2311_/B _2331_/C VDD VDD VSS VSS gf180mcu_fd_sc_mcu7t5v0__aoi21_1
X_3291_ _3291_/A1 _3291_/A2 _3291_/B _4038_/D VDD VDD VSS VSS gf180mcu_fd_sc_mcu7t5v0__aoi21_1
XFILLER_97_335 VDD VDD VSS VSS gf180mcu_fd_sc_mcu7t5v0__fill_1
X_2242_ _4101_/Q _2242_/A2 _2244_/A1 VDD VDD VSS VSS gf180mcu_fd_sc_mcu7t5v0__nor2_1
X_2173_ _4059_/Q _2242_/A2 _2175_/A1 VDD VDD VSS VSS gf180mcu_fd_sc_mcu7t5v0__nor2_1
XFILLER_65_265 VDD VDD VSS VSS gf180mcu_fd_sc_mcu7t5v0__fillcap_8
XFILLER_80_213 VDD VDD VSS VSS gf180mcu_fd_sc_mcu7t5v0__fill_1
XTAP_TAPCELL_ROW_91_797 VDD VSS gf180mcu_fd_sc_mcu7t5v0__filltie
Xclkbuf_leaf_21_ext_clk_in clkbuf_leaf_1_ext_clk_in/I _4162_/CLK VDD VDD VSS VSS gf180mcu_fd_sc_mcu7t5v0__clkbuf_8
X_1957_ _1957_/I _3185_/A1 VDD VDD VSS VSS gf180mcu_fd_sc_mcu7t5v0__clkinv_1
X_1888_ _4124_/Q _3681_/A1 VDD VDD VSS VSS gf180mcu_fd_sc_mcu7t5v0__clkinv_1
X_3627_ _3627_/A1 _3627_/A2 _3627_/A3 _3629_/B1 VDD VDD VSS VSS gf180mcu_fd_sc_mcu7t5v0__nand3_1
X_3558_ _3566_/B _3569_/A2 VDD VDD VSS VSS gf180mcu_fd_sc_mcu7t5v0__clkinv_1
Xoutput18 _3940_/Q PAD_SL[0] VDD VDD VSS VSS gf180mcu_fd_sc_mcu7t5v0__dlyb_1
X_2509_ _2555_/A3 _2510_/B _2509_/Z VDD VDD VSS VSS gf180mcu_fd_sc_mcu7t5v0__and2_1
XFILLER_0_206 VDD VDD VSS VSS gf180mcu_fd_sc_mcu7t5v0__fillcap_32
X_3489_ _4086_/Q _3481_/Z _3538_/B _3490_/A2 VDD VDD VSS VSS gf180mcu_fd_sc_mcu7t5v0__oai21_1
XFILLER_56_37 VDD VDD VSS VSS gf180mcu_fd_sc_mcu7t5v0__fill_2
XFILLER_56_265 VDD VDD VSS VSS gf180mcu_fd_sc_mcu7t5v0__fill_2
XFILLER_16_107 VDD VDD VSS VSS gf180mcu_fd_sc_mcu7t5v0__fill_1
XTAP_TAPCELL_ROW_39_485 VDD VSS gf180mcu_fd_sc_mcu7t5v0__filltie
XFILLER_71_246 VDD VDD VSS VSS gf180mcu_fd_sc_mcu7t5v0__fillcap_16
XTAP_TAPCELL_ROW_82_742 VDD VSS gf180mcu_fd_sc_mcu7t5v0__filltie
XFILLER_24_140 VDD VDD VSS VSS gf180mcu_fd_sc_mcu7t5v0__fillcap_8
XFILLER_8_317 VDD VDD VSS VSS gf180mcu_fd_sc_mcu7t5v0__fillcap_64
XTAP_TAPCELL_ROW_22_385 VDD VSS gf180mcu_fd_sc_mcu7t5v0__filltie
XFILLER_97_66 VDD VDD VSS VSS gf180mcu_fd_sc_mcu7t5v0__fillcap_4
XFILLER_97_88 VDD VDD VSS VSS gf180mcu_fd_sc_mcu7t5v0__fill_1
XTAP_TAPCELL_ROW_117_957 VDD VSS gf180mcu_fd_sc_mcu7t5v0__filltie
Xmax_cap60 _3258_/A1 _3044_/A2 VDD VDD VSS VSS gf180mcu_fd_sc_mcu7t5v0__buf_2
Xmax_cap93 _3848_/Q _3750_/I1 VDD VDD VSS VSS gf180mcu_fd_sc_mcu7t5v0__buf_4
XFILLER_62_268 VDD VDD VSS VSS gf180mcu_fd_sc_mcu7t5v0__fillcap_4
XFILLER_15_195 VDD VDD VSS VSS gf180mcu_fd_sc_mcu7t5v0__fillcap_8
X_2860_ _2929_/A1 _2859_/Z _3908_/D VDD VDD VSS VSS gf180mcu_fd_sc_mcu7t5v0__nor2_1
XTAP_TAPCELL_ROW_13_330 VDD VSS gf180mcu_fd_sc_mcu7t5v0__filltie
X_2791_ _2784_/B _2802_/A3 _2791_/B _2791_/C _2795_/B VDD VDD VSS VSS gf180mcu_fd_sc_mcu7t5v0__aoi211_1
Xtop_level_105 PAD_PDRV0[1] VDD VDD VSS VSS gf180mcu_fd_sc_mcu7t5v0__tieh
X_3412_ _4069_/Q _3410_/Z _3439_/B _3413_/B VDD VDD VSS VSS gf180mcu_fd_sc_mcu7t5v0__oai21_1
Xtop_level_116 trig_out_pdrv_control[0] VDD VDD VSS VSS gf180mcu_fd_sc_mcu7t5v0__tieh
XFILLER_97_110 VDD VDD VSS VSS gf180mcu_fd_sc_mcu7t5v0__fill_2
X_3343_ _3363_/B _3343_/A2 _3342_/Z _4054_/D VDD VDD VSS VSS gf180mcu_fd_sc_mcu7t5v0__nor3_1
X_3274_ _3274_/A1 _3274_/A2 _3274_/B _4030_/D VDD VDD VSS VSS gf180mcu_fd_sc_mcu7t5v0__aoi21_1
XFILLER_97_154 VDD VDD VSS VSS gf180mcu_fd_sc_mcu7t5v0__fill_2
X_2225_ _3796_/Q _2111_/Z _3746_/B _2226_/B VDD VDD VSS VSS gf180mcu_fd_sc_mcu7t5v0__oai21_1
XFILLER_85_349 VDD VDD VSS VSS gf180mcu_fd_sc_mcu7t5v0__fill_1
XTAP_TAPCELL_ROW_108_902 VDD VSS gf180mcu_fd_sc_mcu7t5v0__filltie
XFILLER_38_243 VDD VDD VSS VSS gf180mcu_fd_sc_mcu7t5v0__fill_2
X_2156_ _3772_/Q _2243_/A2 _3746_/B _2157_/A2 VDD VDD VSS VSS gf180mcu_fd_sc_mcu7t5v0__oai21_1
XPHY_EDGE_ROW_5_Right_5 VDD VSS gf180mcu_fd_sc_mcu7t5v0__endcap
X_2087_ _3087_/A1 _3930_/Q _3929_/Q _2087_/B output7/I VDD VDD VSS VSS gf180mcu_fd_sc_mcu7t5v0__oai31_1
XTAP_TAPCELL_ROW_36_466 VDD VSS gf180mcu_fd_sc_mcu7t5v0__filltie
XFILLER_41_419 VDD VDD VSS VSS gf180mcu_fd_sc_mcu7t5v0__fill_1
XFILLER_21_187 VDD VDD VSS VSS gf180mcu_fd_sc_mcu7t5v0__fillcap_8
X_2989_ hold141/Z _3018_/A2 _3018_/B1 _2989_/B2 _2990_/A2 VDD VDD VSS VSS gf180mcu_fd_sc_mcu7t5v0__aoi22_1
XFILLER_88_132 VDD VDD VSS VSS gf180mcu_fd_sc_mcu7t5v0__fill_1
XFILLER_17_416 VDD VDD VSS VSS gf180mcu_fd_sc_mcu7t5v0__fillcap_4
XTAP_TAPCELL_ROW_114_938 VDD VSS gf180mcu_fd_sc_mcu7t5v0__filltie
XFILLER_44_224 VDD VDD VSS VSS gf180mcu_fd_sc_mcu7t5v0__fillcap_16
XFILLER_44_279 VDD VDD VSS VSS gf180mcu_fd_sc_mcu7t5v0__fillcap_4
XPHY_EDGE_ROW_17_Left_139 VDD VSS gf180mcu_fd_sc_mcu7t5v0__endcap
XTAP_TAPCELL_ROW_10_311 VDD VSS gf180mcu_fd_sc_mcu7t5v0__filltie
XPHY_EDGE_ROW_26_Left_148 VDD VSS gf180mcu_fd_sc_mcu7t5v0__endcap
XFILLER_121_240 VDD VDD VSS VSS gf180mcu_fd_sc_mcu7t5v0__fillcap_32
XFILLER_67_349 VDD VDD VSS VSS gf180mcu_fd_sc_mcu7t5v0__fill_1
X_2010_ _2010_/I _3072_/A1 VDD VDD VSS VSS gf180mcu_fd_sc_mcu7t5v0__clkinv_1
XFILLER_35_224 VDD VDD VSS VSS gf180mcu_fd_sc_mcu7t5v0__fill_2
X_3961_ _3961_/D _4155_/CLK _3961_/Q VDD VDD VSS VSS gf180mcu_fd_sc_mcu7t5v0__dffq_1
XPHY_EDGE_ROW_35_Left_157 VDD VSS gf180mcu_fd_sc_mcu7t5v0__endcap
XFILLER_35_279 VDD VDD VSS VSS gf180mcu_fd_sc_mcu7t5v0__fill_1
X_2912_ _2922_/C _2922_/A1 _2922_/A2 _2912_/Z VDD VDD VSS VSS gf180mcu_fd_sc_mcu7t5v0__or3_1
X_3892_ _3892_/D clkload9/I _3892_/Q VDD VDD VSS VSS gf180mcu_fd_sc_mcu7t5v0__dffq_1
X_2843_ _2843_/I _2850_/A3 VDD VDD VSS VSS gf180mcu_fd_sc_mcu7t5v0__clkinv_1
X_2774_ _3955_/Q _3897_/Q _2779_/B VDD VDD VSS VSS gf180mcu_fd_sc_mcu7t5v0__xor2_1
Xhold125 _3819_/Q hold125/Z VDD VDD VSS VSS gf180mcu_fd_sc_mcu7t5v0__dlyc_1
Xhold136 _3937_/Q _2008_/I VDD VDD VSS VSS gf180mcu_fd_sc_mcu7t5v0__dlyc_1
Xhold158 _4053_/Q hold158/Z VDD VDD VSS VSS gf180mcu_fd_sc_mcu7t5v0__dlyc_1
XPHY_EDGE_ROW_44_Left_166 VDD VSS gf180mcu_fd_sc_mcu7t5v0__endcap
Xhold147 _3924_/Q hold147/Z VDD VDD VSS VSS gf180mcu_fd_sc_mcu7t5v0__dlyc_1
Xhold169 _4037_/Q _1908_/I VDD VDD VSS VSS gf180mcu_fd_sc_mcu7t5v0__dlyc_1
X_3326_ _4049_/Q _3324_/Z _3328_/A2 VDD VDD VSS VSS gf180mcu_fd_sc_mcu7t5v0__nor2_1
XFILLER_112_251 VDD VDD VSS VSS gf180mcu_fd_sc_mcu7t5v0__fillcap_4
X_3257_ _3257_/A1 _3257_/A2 _3257_/B _4022_/D VDD VDD VSS VSS gf180mcu_fd_sc_mcu7t5v0__aoi21_1
X_3188_ _3290_/A1 wire44/Z wire81/I _3189_/B VDD VDD VSS VSS gf180mcu_fd_sc_mcu7t5v0__oai21_1
X_2208_ _2208_/A1 _2208_/A2 _3789_/D VDD VDD VSS VSS gf180mcu_fd_sc_mcu7t5v0__nor2_1
XPHY_EDGE_ROW_53_Left_175 VDD VSS gf180mcu_fd_sc_mcu7t5v0__endcap
X_2139_ _2139_/A1 _2139_/A2 _3766_/D VDD VDD VSS VSS gf180mcu_fd_sc_mcu7t5v0__nor2_1
XFILLER_14_419 VDD VDD VSS VSS gf180mcu_fd_sc_mcu7t5v0__fillcap_4
XFILLER_81_352 VDD VDD VSS VSS gf180mcu_fd_sc_mcu7t5v0__fill_2
XTAP_TAPCELL_ROW_111_919 VDD VSS gf180mcu_fd_sc_mcu7t5v0__filltie
XFILLER_5_106 VDD VDD VSS VSS gf180mcu_fd_sc_mcu7t5v0__fillcap_8
XPHY_EDGE_ROW_62_Left_184 VDD VSS gf180mcu_fd_sc_mcu7t5v0__endcap
XFILLER_78_24 VDD VDD VSS VSS gf180mcu_fd_sc_mcu7t5v0__fill_1
XPHY_EDGE_ROW_71_Left_193 VDD VSS gf180mcu_fd_sc_mcu7t5v0__endcap
XFILLER_94_56 VDD VDD VSS VSS gf180mcu_fd_sc_mcu7t5v0__fillcap_16
XFILLER_27_72 VDD VDD VSS VSS gf180mcu_fd_sc_mcu7t5v0__fill_1
XFILLER_17_246 VDD VDD VSS VSS gf180mcu_fd_sc_mcu7t5v0__fillcap_16
Xclkbuf_leaf_0__1473_ clkbuf_leaf_5__1473_/I _3545_/A3 VDD VDD VSS VSS gf180mcu_fd_sc_mcu7t5v0__clkbuf_8
XFILLER_94_89 VDD VDD VSS VSS gf180mcu_fd_sc_mcu7t5v0__fill_2
XTAP_TAPCELL_ROW_55_583 VDD VSS gf180mcu_fd_sc_mcu7t5v0__filltie
X_2490_ _2490_/A1 _2489_/C _2490_/B _3868_/D VDD VDD VSS VSS gf180mcu_fd_sc_mcu7t5v0__aoi21_1
X_4160_ input4/Z _4162_/CLK _4160_/Q VDD VDD VSS VSS gf180mcu_fd_sc_mcu7t5v0__dffq_1
X_3111_ _3111_/A1 _3121_/A2 _3111_/B _3953_/D VDD VDD VSS VSS gf180mcu_fd_sc_mcu7t5v0__aoi21_1
XFILLER_95_422 VDD VDD VSS VSS gf180mcu_fd_sc_mcu7t5v0__fillcap_4
X_4091_ _4091_/D clkload4/I _4091_/Q VDD VDD VSS VSS gf180mcu_fd_sc_mcu7t5v0__dffq_1
X_3042_ _3968_/Q _3139_/A1 _3042_/B1 _3952_/Q _3043_/A4 VDD VDD VSS VSS gf180mcu_fd_sc_mcu7t5v0__aoi22_1
X_3944_ _3944_/D _4017_/CLK _3944_/Q VDD VDD VSS VSS gf180mcu_fd_sc_mcu7t5v0__dffq_1
X_3875_ _3875_/D clkload7/I _3875_/Q VDD VDD VSS VSS gf180mcu_fd_sc_mcu7t5v0__dffq_1
X_2826_ _3962_/Q _3904_/Q _2827_/I VDD VDD VSS VSS gf180mcu_fd_sc_mcu7t5v0__xnor2_1
XFILLER_31_282 VDD VDD VSS VSS gf180mcu_fd_sc_mcu7t5v0__fillcap_16
X_2757_ _2751_/Z _2755_/Z _2757_/Z VDD VDD VSS VSS gf180mcu_fd_sc_mcu7t5v0__and2_1
XFILLER_117_387 VDD VDD VSS VSS gf180mcu_fd_sc_mcu7t5v0__fillcap_32
X_2688_ _2678_/B _2688_/A2 _2688_/A3 _2689_/A2 VDD VDD VSS VSS gf180mcu_fd_sc_mcu7t5v0__nor3_1
XFILLER_100_210 VDD VDD VSS VSS gf180mcu_fd_sc_mcu7t5v0__fillcap_4
XFILLER_58_157 VDD VDD VSS VSS gf180mcu_fd_sc_mcu7t5v0__fillcap_8
X_3309_ _3363_/B _3309_/A2 _3308_/Z _4043_/D VDD VDD VSS VSS gf180mcu_fd_sc_mcu7t5v0__nor3_1
XTAP_TAPCELL_ROW_69_664 VDD VSS gf180mcu_fd_sc_mcu7t5v0__filltie
XFILLER_100_276 VDD VDD VSS VSS gf180mcu_fd_sc_mcu7t5v0__fillcap_4
XFILLER_104_99 VDD VDD VSS VSS gf180mcu_fd_sc_mcu7t5v0__fillcap_4
XTAP_TAPCELL_ROW_52_564 VDD VSS gf180mcu_fd_sc_mcu7t5v0__filltie
XFILLER_108_321 VDD VDD VSS VSS gf180mcu_fd_sc_mcu7t5v0__fill_1
XFILLER_89_56 VDD VDD VSS VSS gf180mcu_fd_sc_mcu7t5v0__fillcap_8
XFILLER_108_376 VDD VDD VSS VSS gf180mcu_fd_sc_mcu7t5v0__fill_1
XFILLER_1_142 VDD VDD VSS VSS gf180mcu_fd_sc_mcu7t5v0__fillcap_8
XFILLER_1_131 VDD VDD VSS VSS gf180mcu_fd_sc_mcu7t5v0__fill_1
XFILLER_96_208 VDD VDD VSS VSS gf180mcu_fd_sc_mcu7t5v0__fill_1
XFILLER_1_186 VDD VDD VSS VSS gf180mcu_fd_sc_mcu7t5v0__fill_1
XFILLER_77_422 VDD VDD VSS VSS gf180mcu_fd_sc_mcu7t5v0__fillcap_4
XFILLER_89_282 VDD VDD VSS VSS gf180mcu_fd_sc_mcu7t5v0__fillcap_8
X_1990_ _3955_/Q _3115_/A1 VDD VDD VSS VSS gf180mcu_fd_sc_mcu7t5v0__clkinv_1
XPHY_EDGE_ROW_109_Left_231 VDD VSS gf180mcu_fd_sc_mcu7t5v0__endcap
XFILLER_118_107 VDD VDD VSS VSS gf180mcu_fd_sc_mcu7t5v0__fill_1
X_3660_ hold204/Z _3669_/A2 _3669_/B1 _3660_/B2 _3661_/A2 VDD VDD VSS VSS gf180mcu_fd_sc_mcu7t5v0__aoi22_1
Xclkload34 _3545_/A3 clkload34/Z VDD VDD VSS VSS gf180mcu_fd_sc_mcu7t5v0__clkbuf_8
Xclkload12 _4166_/CLK clkload12/ZN VDD VDD VSS VSS gf180mcu_fd_sc_mcu7t5v0__clkinv_4
X_3591_ _3592_/A1 _2947_/Z _3662_/B1 VDD VDD VSS VSS gf180mcu_fd_sc_mcu7t5v0__nor2_1
X_2611_ _2622_/B _2620_/B _2618_/A2 VDD VDD VSS VSS gf180mcu_fd_sc_mcu7t5v0__nand2_1
Xclkload23 _4073_/CLK clkload23/ZN VDD VDD VSS VSS gf180mcu_fd_sc_mcu7t5v0__inv_2
X_2542_ _2542_/A1 _2538_/B _2542_/A3 _2548_/B1 VDD VDD VSS VSS gf180mcu_fd_sc_mcu7t5v0__nor3_1
XPHY_EDGE_ROW_118_Left_240 VDD VSS gf180mcu_fd_sc_mcu7t5v0__endcap
X_2473_ _2473_/A1 _2473_/A2 _2474_/I0 VDD VDD VSS VSS gf180mcu_fd_sc_mcu7t5v0__nand2_1
X_4143_ _4143_/D _4149_/CLK _4143_/Q VDD VDD VSS VSS gf180mcu_fd_sc_mcu7t5v0__dffq_1
X_4074_ _4074_/D _4079_/CLK _4074_/Q VDD VDD VSS VSS gf180mcu_fd_sc_mcu7t5v0__dffq_1
XFILLER_55_116 VDD VDD VSS VSS gf180mcu_fd_sc_mcu7t5v0__fill_1
X_3025_ _3983_/Q _3037_/C2 _3190_/A1 _3991_/Q _4023_/Q _3044_/A2 _3026_/I VDD VDD
+ VSS VSS gf180mcu_fd_sc_mcu7t5v0__aoi222_1
XFILLER_11_208 VDD VDD VSS VSS gf180mcu_fd_sc_mcu7t5v0__fill_2
X_3927_ _3927_/D _4142_/CLK _3927_/Q VDD VDD VSS VSS gf180mcu_fd_sc_mcu7t5v0__dffq_1
X_3858_ _3858_/D _4021_/CLK _3858_/Q VDD VDD VSS VSS gf180mcu_fd_sc_mcu7t5v0__dffq_1
Xclkload6 clkload6/I clkload6/ZN VDD VDD VSS VSS gf180mcu_fd_sc_mcu7t5v0__inv_4
X_2809_ _3959_/Q _3901_/Q _2810_/I VDD VDD VSS VSS gf180mcu_fd_sc_mcu7t5v0__xor2_1
X_3789_ _3789_/D clkload4/I _3789_/Q VDD VDD VSS VSS gf180mcu_fd_sc_mcu7t5v0__dffq_1
XFILLER_59_15 VDD VDD VSS VSS gf180mcu_fd_sc_mcu7t5v0__fillcap_16
XTAP_TAPCELL_ROW_6_289 VDD VSS gf180mcu_fd_sc_mcu7t5v0__filltie
Xload_slew29 _2929_/A1 _2760_/C VDD VDD VSS VSS gf180mcu_fd_sc_mcu7t5v0__clkbuf_8
XFILLER_27_385 VDD VDD VSS VSS gf180mcu_fd_sc_mcu7t5v0__fill_2
XTAP_TAPCELL_ROW_88_781 VDD VSS gf180mcu_fd_sc_mcu7t5v0__filltie
XFILLER_60_174 VDD VDD VSS VSS gf180mcu_fd_sc_mcu7t5v0__fill_1
Xclkbuf_leaf_11_ext_clk_in clkload0/I _4104_/CLK VDD VDD VSS VSS gf180mcu_fd_sc_mcu7t5v0__clkbuf_8
XTAP_TAPCELL_ROW_71_681 VDD VSS gf180mcu_fd_sc_mcu7t5v0__filltie
X_1973_ _3972_/Q _3151_/A1 VDD VDD VSS VSS gf180mcu_fd_sc_mcu7t5v0__clkinv_1
XFILLER_119_416 VDD VDD VSS VSS gf180mcu_fd_sc_mcu7t5v0__fillcap_4
X_3712_ _3754_/I1 _3717_/A2 _3714_/A1 VDD VDD VSS VSS gf180mcu_fd_sc_mcu7t5v0__nor2_1
X_3643_ _3763_/Q _3662_/A2 _3663_/B1 _3771_/Q _3645_/A2 VDD VDD VSS VSS gf180mcu_fd_sc_mcu7t5v0__aoi22_1
X_3574_ _3574_/A1 _3574_/A2 _3574_/B _4110_/D VDD VDD VSS VSS gf180mcu_fd_sc_mcu7t5v0__oai21_1
X_2525_ _2525_/A1 _2525_/A2 _3873_/Q _2525_/A4 _2526_/B VDD VDD VSS VSS gf180mcu_fd_sc_mcu7t5v0__nor4_1
X_2456_ _2475_/A2 _2455_/Z _2495_/B1 VDD VDD VSS VSS gf180mcu_fd_sc_mcu7t5v0__nand2_1
XFILLER_29_18 VDD VDD VSS VSS gf180mcu_fd_sc_mcu7t5v0__fillcap_8
X_2387_ _2387_/I _3837_/D VDD VDD VSS VSS gf180mcu_fd_sc_mcu7t5v0__clkinv_1
X_4126_ _4126_/D _4164_/CLK _4126_/Q VDD VDD VSS VSS gf180mcu_fd_sc_mcu7t5v0__dffq_1
XFILLER_110_393 VDD VDD VSS VSS gf180mcu_fd_sc_mcu7t5v0__fillcap_32
X_4057_ _4057_/D _4058_/CLK _4057_/Q VDD VDD VSS VSS gf180mcu_fd_sc_mcu7t5v0__dffq_1
XFILLER_36_160 VDD VDD VSS VSS gf180mcu_fd_sc_mcu7t5v0__fillcap_8
X_3008_ _3008_/A1 _3008_/A2 _3007_/Z _3009_/B2 VDD VDD VSS VSS gf180mcu_fd_sc_mcu7t5v0__nand3_1
XFILLER_71_417 VDD VDD VSS VSS gf180mcu_fd_sc_mcu7t5v0__fill_2
XFILLER_36_193 VDD VDD VSS VSS gf180mcu_fd_sc_mcu7t5v0__fillcap_8
XFILLER_10_31 VDD VDD VSS VSS gf180mcu_fd_sc_mcu7t5v0__fillcap_4
XFILLER_120_168 VDD VDD VSS VSS gf180mcu_fd_sc_mcu7t5v0__fillcap_4
XFILLER_74_244 VDD VDD VSS VSS gf180mcu_fd_sc_mcu7t5v0__fill_1
XFILLER_74_266 VDD VDD VSS VSS gf180mcu_fd_sc_mcu7t5v0__fillcap_8
XTAP_TAPCELL_ROW_85_762 VDD VSS gf180mcu_fd_sc_mcu7t5v0__filltie
XFILLER_27_171 VDD VDD VSS VSS gf180mcu_fd_sc_mcu7t5v0__fill_2
XFILLER_74_288 VDD VDD VSS VSS gf180mcu_fd_sc_mcu7t5v0__fill_1
XFILLER_74_299 VDD VDD VSS VSS gf180mcu_fd_sc_mcu7t5v0__fill_2
XFILLER_27_182 VDD VDD VSS VSS gf180mcu_fd_sc_mcu7t5v0__fillcap_4
XFILLER_35_72 VDD VDD VSS VSS gf180mcu_fd_sc_mcu7t5v0__fillcap_4
XFILLER_35_94 VDD VDD VSS VSS gf180mcu_fd_sc_mcu7t5v0__fillcap_16
XFILLER_116_419 VDD VDD VSS VSS gf180mcu_fd_sc_mcu7t5v0__fillcap_4
X_2310_ _4159_/Q _2252_/Z _2339_/A2 VDD VDD VSS VSS gf180mcu_fd_sc_mcu7t5v0__nand2_1
X_3290_ _3290_/A1 _3291_/A2 wire81/Z _3291_/B VDD VDD VSS VSS gf180mcu_fd_sc_mcu7t5v0__oai21_1
XFILLER_97_303 VDD VDD VSS VSS gf180mcu_fd_sc_mcu7t5v0__fillcap_8
X_2241_ _2241_/A1 _2241_/A2 hold164/I VDD VDD VSS VSS gf180mcu_fd_sc_mcu7t5v0__nor2_1
XFILLER_38_403 VDD VDD VSS VSS gf180mcu_fd_sc_mcu7t5v0__fillcap_16
XFILLER_38_425 VDD VDD VSS VSS gf180mcu_fd_sc_mcu7t5v0__fill_1
X_2172_ _2172_/A1 _2172_/A2 hold155/I VDD VDD VSS VSS gf180mcu_fd_sc_mcu7t5v0__nor2_1
XFILLER_53_406 VDD VDD VSS VSS gf180mcu_fd_sc_mcu7t5v0__fill_1
XFILLER_65_233 VDD VDD VSS VSS gf180mcu_fd_sc_mcu7t5v0__fill_2
XFILLER_65_277 VDD VDD VSS VSS gf180mcu_fd_sc_mcu7t5v0__fill_2
XFILLER_80_203 VDD VDD VSS VSS gf180mcu_fd_sc_mcu7t5v0__fillcap_8
XFILLER_80_247 VDD VDD VSS VSS gf180mcu_fd_sc_mcu7t5v0__fillcap_8
XTAP_TAPCELL_ROW_16_350 VDD VSS gf180mcu_fd_sc_mcu7t5v0__filltie
XTAP_TAPCELL_ROW_91_798 VDD VSS gf180mcu_fd_sc_mcu7t5v0__filltie
X_1956_ _3989_/Q _3187_/A1 VDD VDD VSS VSS gf180mcu_fd_sc_mcu7t5v0__clkinv_1
XFILLER_119_279 VDD VDD VSS VSS gf180mcu_fd_sc_mcu7t5v0__fill_1
XFILLER_119_257 VDD VDD VSS VSS gf180mcu_fd_sc_mcu7t5v0__fillcap_4
X_1887_ _4125_/Q _3683_/A1 VDD VDD VSS VSS gf180mcu_fd_sc_mcu7t5v0__clkinv_1
X_3626_ _3761_/Q _3662_/A2 _3663_/B1 _3769_/Q _3627_/A3 VDD VDD VSS VSS gf180mcu_fd_sc_mcu7t5v0__aoi22_1
Xoutput19 _3939_/Q PAD_SL[1] VDD VDD VSS VSS gf180mcu_fd_sc_mcu7t5v0__dlyb_1
X_3557_ _3557_/A1 _3554_/Z _3572_/A2 _3557_/B _3566_/B VDD VDD VSS VSS gf180mcu_fd_sc_mcu7t5v0__oai31_1
X_2508_ _2500_/Z _2510_/B _2538_/A1 _2525_/A4 VDD VDD VSS VSS gf180mcu_fd_sc_mcu7t5v0__nand3_1
XFILLER_88_314 VDD VDD VSS VSS gf180mcu_fd_sc_mcu7t5v0__fill_1
XFILLER_102_102 VDD VDD VSS VSS gf180mcu_fd_sc_mcu7t5v0__fill_2
X_3488_ _4086_/Q _3498_/A2 _3549_/B _3488_/B2 _3490_/A1 VDD VDD VSS VSS gf180mcu_fd_sc_mcu7t5v0__aoi22_1
XFILLER_102_113 VDD VDD VSS VSS gf180mcu_fd_sc_mcu7t5v0__fill_1
X_2439_ _2439_/A1 _2439_/A2 _3857_/D VDD VDD VSS VSS gf180mcu_fd_sc_mcu7t5v0__nor2_1
XFILLER_88_369 VDD VDD VSS VSS gf180mcu_fd_sc_mcu7t5v0__fill_2
X_4109_ _4109_/D clkload5/I _4109_/Q VDD VDD VSS VSS gf180mcu_fd_sc_mcu7t5v0__dffq_1
XFILLER_56_255 VDD VDD VSS VSS gf180mcu_fd_sc_mcu7t5v0__fillcap_4
XFILLER_56_244 VDD VDD VSS VSS gf180mcu_fd_sc_mcu7t5v0__fill_1
XTAP_TAPCELL_ROW_39_486 VDD VSS gf180mcu_fd_sc_mcu7t5v0__filltie
XFILLER_44_417 VDD VDD VSS VSS gf180mcu_fd_sc_mcu7t5v0__fillcap_8
XFILLER_71_203 VDD VDD VSS VSS gf180mcu_fd_sc_mcu7t5v0__fill_1
XTAP_TAPCELL_ROW_82_743 VDD VSS gf180mcu_fd_sc_mcu7t5v0__filltie
XFILLER_24_152 VDD VDD VSS VSS gf180mcu_fd_sc_mcu7t5v0__fill_2
XFILLER_24_174 VDD VDD VSS VSS gf180mcu_fd_sc_mcu7t5v0__fill_1
XTAP_TAPCELL_ROW_22_386 VDD VSS gf180mcu_fd_sc_mcu7t5v0__filltie
XFILLER_21_63 VDD VDD VSS VSS gf180mcu_fd_sc_mcu7t5v0__fillcap_4
XFILLER_94_317 VDD VDD VSS VSS gf180mcu_fd_sc_mcu7t5v0__fillcap_4
XFILLER_46_93 VDD VDD VSS VSS gf180mcu_fd_sc_mcu7t5v0__fillcap_4
Xmax_cap50 _2999_/B1 _3018_/B1 VDD VDD VSS VSS gf180mcu_fd_sc_mcu7t5v0__clkbuf_2
Xmax_cap61 _3040_/B1 _3057_/A1 VDD VDD VSS VSS gf180mcu_fd_sc_mcu7t5v0__buf_2
Xmax_cap72 _3013_/B1 _3190_/A1 VDD VDD VSS VSS gf180mcu_fd_sc_mcu7t5v0__buf_2
XFILLER_62_247 VDD VDD VSS VSS gf180mcu_fd_sc_mcu7t5v0__fillcap_8
XFILLER_15_163 VDD VDD VSS VSS gf180mcu_fd_sc_mcu7t5v0__fillcap_4
XTAP_TAPCELL_ROW_13_331 VDD VSS gf180mcu_fd_sc_mcu7t5v0__filltie
Xclkbuf_1_0__f__1533_ clkbuf_0__1533_/Z _3538_/A2 VDD VDD VSS VSS gf180mcu_fd_sc_mcu7t5v0__clkbuf_16
X_2790_ _2784_/B _2802_/A3 _2791_/C _2792_/A2 VDD VDD VSS VSS gf180mcu_fd_sc_mcu7t5v0__aoi21_1
XFILLER_30_177 VDD VDD VSS VSS gf180mcu_fd_sc_mcu7t5v0__fill_2
XFILLER_62_92 VDD VDD VSS VSS gf180mcu_fd_sc_mcu7t5v0__fill_1
X_3411_ _3401_/I _3411_/A2 _3410_/Z _4068_/D VDD VDD VSS VSS gf180mcu_fd_sc_mcu7t5v0__nor3_1
Xtop_level_117 trig_out_pdrv_control[1] VDD VDD VSS VSS gf180mcu_fd_sc_mcu7t5v0__tieh
Xtop_level_106 PAD_PDRV1[0] VDD VDD VSS VSS gf180mcu_fd_sc_mcu7t5v0__tieh
X_3342_ _4054_/Q _3339_/Z _3342_/Z VDD VDD VSS VSS gf180mcu_fd_sc_mcu7t5v0__and2_1
XFILLER_97_133 VDD VDD VSS VSS gf180mcu_fd_sc_mcu7t5v0__fill_2
X_3273_ _3290_/A1 _3274_/A2 wire81/Z _3274_/B VDD VDD VSS VSS gf180mcu_fd_sc_mcu7t5v0__oai21_1
X_2224_ _2224_/A1 _2224_/A2 _3795_/D VDD VDD VSS VSS gf180mcu_fd_sc_mcu7t5v0__nor2_1
XTAP_TAPCELL_ROW_108_903 VDD VSS gf180mcu_fd_sc_mcu7t5v0__filltie
X_2155_ hold158/Z _2155_/A2 _2157_/A1 VDD VDD VSS VSS gf180mcu_fd_sc_mcu7t5v0__nor2_1
Xclkbuf_leaf_1_ext_clk_in clkbuf_leaf_1_ext_clk_in/I clkload2/I VDD VDD VSS VSS gf180mcu_fd_sc_mcu7t5v0__clkbuf_8
X_2086_ _3085_/A1 _3930_/Q _3929_/Q _2087_/B output6/I VDD VDD VSS VSS gf180mcu_fd_sc_mcu7t5v0__oai31_1
XTAP_TAPCELL_ROW_36_467 VDD VSS gf180mcu_fd_sc_mcu7t5v0__filltie
X_2988_ _2988_/A1 _2988_/A2 _2988_/A3 _2988_/A4 _2989_/B2 VDD VDD VSS VSS gf180mcu_fd_sc_mcu7t5v0__nand4_1
X_1939_ _1939_/I _3223_/A1 VDD VDD VSS VSS gf180mcu_fd_sc_mcu7t5v0__clkinv_1
XFILLER_107_216 VDD VDD VSS VSS gf180mcu_fd_sc_mcu7t5v0__fill_2
X_3609_ _3609_/A1 _3609_/A2 _3609_/A3 _3611_/C1 VDD VDD VSS VSS gf180mcu_fd_sc_mcu7t5v0__nand3_1
XFILLER_103_422 VDD VDD VSS VSS gf180mcu_fd_sc_mcu7t5v0__fillcap_4
XFILLER_107_55 VDD VDD VSS VSS gf180mcu_fd_sc_mcu7t5v0__fill_2
XFILLER_84_350 VDD VDD VSS VSS gf180mcu_fd_sc_mcu7t5v0__fill_1
XTAP_TAPCELL_ROW_114_939 VDD VSS gf180mcu_fd_sc_mcu7t5v0__filltie
XTAP_TAPCELL_ROW_27_412 VDD VSS gf180mcu_fd_sc_mcu7t5v0__filltie
XFILLER_44_247 VDD VDD VSS VSS gf180mcu_fd_sc_mcu7t5v0__fill_2
XFILLER_16_41 VDD VDD VSS VSS gf180mcu_fd_sc_mcu7t5v0__fill_2
XPHY_EDGE_ROW_11_Right_11 VDD VSS gf180mcu_fd_sc_mcu7t5v0__endcap
XFILLER_52_280 VDD VDD VSS VSS gf180mcu_fd_sc_mcu7t5v0__fill_2
XFILLER_8_104 VDD VDD VSS VSS gf180mcu_fd_sc_mcu7t5v0__fill_1
XTAP_TAPCELL_ROW_10_312 VDD VSS gf180mcu_fd_sc_mcu7t5v0__filltie
XFILLER_8_148 VDD VDD VSS VSS gf180mcu_fd_sc_mcu7t5v0__fillcap_4
XPHY_EDGE_ROW_20_Right_20 VDD VSS gf180mcu_fd_sc_mcu7t5v0__endcap
XFILLER_4_387 VDD VDD VSS VSS gf180mcu_fd_sc_mcu7t5v0__fillcap_32
XFILLER_79_166 VDD VDD VSS VSS gf180mcu_fd_sc_mcu7t5v0__fill_1
XFILLER_121_274 VDD VDD VSS VSS gf180mcu_fd_sc_mcu7t5v0__fill_2
XFILLER_90_331 VDD VDD VSS VSS gf180mcu_fd_sc_mcu7t5v0__fill_1
X_3960_ _3960_/D _4034_/CLK _3960_/Q VDD VDD VSS VSS gf180mcu_fd_sc_mcu7t5v0__dffq_1
XFILLER_73_80 VDD VDD VSS VSS gf180mcu_fd_sc_mcu7t5v0__fillcap_4
X_2911_ _2922_/A1 _2922_/A2 _2922_/C _2920_/A2 VDD VDD VSS VSS gf180mcu_fd_sc_mcu7t5v0__oai21_1
X_3891_ _3891_/D clkload9/I _3891_/Q VDD VDD VSS VSS gf180mcu_fd_sc_mcu7t5v0__dffq_1
XTAP_TAPCELL_ROW_33_448 VDD VSS gf180mcu_fd_sc_mcu7t5v0__filltie
X_2842_ _3964_/Q _3906_/Q _2843_/I VDD VDD VSS VSS gf180mcu_fd_sc_mcu7t5v0__nor2_1
X_2773_ _2760_/C _2773_/A2 _3896_/D VDD VDD VSS VSS gf180mcu_fd_sc_mcu7t5v0__nor2_1
Xhold126 _4167_/Q hold126/Z VDD VDD VSS VSS gf180mcu_fd_sc_mcu7t5v0__dlyc_1
Xhold159 _4117_/Q hold159/Z VDD VDD VSS VSS gf180mcu_fd_sc_mcu7t5v0__dlyc_1
Xhold148 _4041_/Q hold148/Z VDD VDD VSS VSS gf180mcu_fd_sc_mcu7t5v0__dlyc_1
Xhold137 _4145_/Q hold137/Z VDD VDD VSS VSS gf180mcu_fd_sc_mcu7t5v0__dlyc_1
X_3325_ _3395_/A1 _3325_/A2 _3324_/Z _4048_/D VDD VDD VSS VSS gf180mcu_fd_sc_mcu7t5v0__nor3_1
XFILLER_112_230 VDD VDD VSS VSS gf180mcu_fd_sc_mcu7t5v0__fillcap_8
X_3256_ _3290_/A1 _3257_/A2 _3256_/B _3257_/B VDD VDD VSS VSS gf180mcu_fd_sc_mcu7t5v0__oai21_1
XFILLER_58_317 VDD VDD VSS VSS gf180mcu_fd_sc_mcu7t5v0__fillcap_4
XFILLER_100_414 VDD VDD VSS VSS gf180mcu_fd_sc_mcu7t5v0__fillcap_8
XFILLER_100_403 VDD VDD VSS VSS gf180mcu_fd_sc_mcu7t5v0__fill_2
XFILLER_37_18 VDD VDD VSS VSS gf180mcu_fd_sc_mcu7t5v0__fillcap_32
X_2207_ _3789_/Q _2111_/Z _3746_/B _2208_/A2 VDD VDD VSS VSS gf180mcu_fd_sc_mcu7t5v0__oai21_1
X_3187_ _3187_/A1 wire44/Z _3187_/B _3989_/D VDD VDD VSS VSS gf180mcu_fd_sc_mcu7t5v0__aoi21_1
X_2138_ hold229/Z _2243_/A2 _3746_/B _2139_/A2 VDD VDD VSS VSS gf180mcu_fd_sc_mcu7t5v0__oai21_1
X_2069_ _3888_/Q _2716_/A2 VDD VDD VSS VSS gf180mcu_fd_sc_mcu7t5v0__clkinv_1
XFILLER_64_309 VDD VDD VSS VSS gf180mcu_fd_sc_mcu7t5v0__fill_1
XFILLER_27_40 VDD VDD VSS VSS gf180mcu_fd_sc_mcu7t5v0__fill_1
XFILLER_91_139 VDD VDD VSS VSS gf180mcu_fd_sc_mcu7t5v0__fill_1
XTAP_TAPCELL_ROW_55_584 VDD VSS gf180mcu_fd_sc_mcu7t5v0__filltie
XFILLER_43_72 VDD VDD VSS VSS gf180mcu_fd_sc_mcu7t5v0__fillcap_8
XFILLER_40_283 VDD VDD VSS VSS gf180mcu_fd_sc_mcu7t5v0__fill_2
X_3110_ _3849_/Q _3121_/A2 _3256_/B _3111_/B VDD VDD VSS VSS gf180mcu_fd_sc_mcu7t5v0__oai21_1
X_4090_ _4090_/D clkload4/I _4090_/Q VDD VDD VSS VSS gf180mcu_fd_sc_mcu7t5v0__dffq_1
X_3041_ _3932_/Q _3060_/A1 _3088_/A1 _3944_/Q _3043_/A3 VDD VDD VSS VSS gf180mcu_fd_sc_mcu7t5v0__aoi22_1
X_3943_ _3943_/D clkload1/I _3943_/Q VDD VDD VSS VSS gf180mcu_fd_sc_mcu7t5v0__dffq_1
X_3874_ _3874_/D clkload6/I _3874_/Q VDD VDD VSS VSS gf180mcu_fd_sc_mcu7t5v0__dffq_1
XFILLER_31_261 VDD VDD VSS VSS gf180mcu_fd_sc_mcu7t5v0__fill_1
X_2825_ _2929_/A1 _2824_/Z _3903_/D VDD VDD VSS VSS gf180mcu_fd_sc_mcu7t5v0__nor2_1
XFILLER_117_311 VDD VDD VSS VSS gf180mcu_fd_sc_mcu7t5v0__fillcap_4
X_2756_ _3107_/A1 _2756_/A2 _2756_/B _2759_/A2 VDD VDD VSS VSS gf180mcu_fd_sc_mcu7t5v0__oai21_1
X_2687_ _4026_/Q _2687_/A2 _2687_/B _4025_/Q _2688_/A3 VDD VDD VSS VSS gf180mcu_fd_sc_mcu7t5v0__aoi211_1
XFILLER_58_103 VDD VDD VSS VSS gf180mcu_fd_sc_mcu7t5v0__fill_2
X_3308_ _4043_/Q _3305_/Z _3308_/Z VDD VDD VSS VSS gf180mcu_fd_sc_mcu7t5v0__and2_1
X_3239_ _3290_/A1 _3240_/A2 wire81/I _3240_/B VDD VDD VSS VSS gf180mcu_fd_sc_mcu7t5v0__oai21_1
XTAP_TAPCELL_ROW_69_665 VDD VSS gf180mcu_fd_sc_mcu7t5v0__filltie
XFILLER_104_34 VDD VDD VSS VSS gf180mcu_fd_sc_mcu7t5v0__fill_1
XFILLER_73_139 VDD VDD VSS VSS gf180mcu_fd_sc_mcu7t5v0__fill_1
XFILLER_14_217 VDD VDD VSS VSS gf180mcu_fd_sc_mcu7t5v0__fillcap_8
XFILLER_120_77 VDD VDD VSS VSS gf180mcu_fd_sc_mcu7t5v0__fill_1
XTAP_TAPCELL_ROW_52_565 VDD VSS gf180mcu_fd_sc_mcu7t5v0__filltie
XFILLER_22_294 VDD VDD VSS VSS gf180mcu_fd_sc_mcu7t5v0__fillcap_8
XFILLER_22_272 VDD VDD VSS VSS gf180mcu_fd_sc_mcu7t5v0__fill_2
XFILLER_13_31 VDD VDD VSS VSS gf180mcu_fd_sc_mcu7t5v0__fill_1
XFILLER_10_423 VDD VDD VSS VSS gf180mcu_fd_sc_mcu7t5v0__fill_2
XFILLER_8_2 VDD VDD VSS VSS gf180mcu_fd_sc_mcu7t5v0__fillcap_32
XFILLER_89_79 VDD VDD VSS VSS gf180mcu_fd_sc_mcu7t5v0__fillcap_8
XFILLER_89_68 VDD VDD VSS VSS gf180mcu_fd_sc_mcu7t5v0__fill_2
XFILLER_1_154 VDD VDD VSS VSS gf180mcu_fd_sc_mcu7t5v0__fill_2
XFILLER_49_169 VDD VDD VSS VSS gf180mcu_fd_sc_mcu7t5v0__fill_1
XFILLER_38_94 VDD VDD VSS VSS gf180mcu_fd_sc_mcu7t5v0__fill_2
XTAP_TAPCELL_ROW_43_510 VDD VSS gf180mcu_fd_sc_mcu7t5v0__filltie
XFILLER_72_161 VDD VDD VSS VSS gf180mcu_fd_sc_mcu7t5v0__fill_2
XFILLER_54_93 VDD VDD VSS VSS gf180mcu_fd_sc_mcu7t5v0__fill_2
XFILLER_13_261 VDD VDD VSS VSS gf180mcu_fd_sc_mcu7t5v0__fill_2
XFILLER_13_272 VDD VDD VSS VSS gf180mcu_fd_sc_mcu7t5v0__fill_2
XFILLER_9_276 VDD VDD VSS VSS gf180mcu_fd_sc_mcu7t5v0__fillcap_4
Xclkload35 _3536_/C clkload35/ZN VDD VDD VSS VSS gf180mcu_fd_sc_mcu7t5v0__clkinv_3
Xclkload24 _3455_/A3 clkload24/Z VDD VDD VSS VSS gf180mcu_fd_sc_mcu7t5v0__clkbuf_2
X_3590_ _3592_/A1 _3597_/A2 _3662_/A2 VDD VDD VSS VSS gf180mcu_fd_sc_mcu7t5v0__nor2_1
Xclkload13 _4169_/CLK clkload13/ZN VDD VDD VSS VSS gf180mcu_fd_sc_mcu7t5v0__inv_4
X_2610_ _3213_/A1 _3911_/Q _2620_/B VDD VDD VSS VSS gf180mcu_fd_sc_mcu7t5v0__nand2_1
X_2541_ _2543_/B1 _2541_/A2 _2541_/B _3876_/D VDD VDD VSS VSS gf180mcu_fd_sc_mcu7t5v0__aoi21_1
X_2472_ _4115_/Q _3926_/Q _2496_/B _2473_/A2 VDD VDD VSS VSS gf180mcu_fd_sc_mcu7t5v0__oai21_1
X_4142_ _4142_/D _4142_/CLK _4142_/Q VDD VDD VSS VSS gf180mcu_fd_sc_mcu7t5v0__dffq_1
X_4073_ _4073_/D _4073_/CLK _4073_/Q VDD VDD VSS VSS gf180mcu_fd_sc_mcu7t5v0__dffq_1
X_3024_ _3967_/Q _3139_/A1 _3042_/B1 _3951_/Q _3049_/B1 _4165_/Q _3032_/A2 VDD VDD
+ VSS VSS gf180mcu_fd_sc_mcu7t5v0__aoi222_1
XTAP_TAPCELL_ROW_66_646 VDD VSS gf180mcu_fd_sc_mcu7t5v0__filltie
XFILLER_63_150 VDD VDD VSS VSS gf180mcu_fd_sc_mcu7t5v0__fillcap_4
X_3926_ _3926_/D clkload2/I _3926_/Q VDD VDD VSS VSS gf180mcu_fd_sc_mcu7t5v0__dffq_1
X_3857_ _3857_/D clkload8/I _3857_/Q VDD VDD VSS VSS gf180mcu_fd_sc_mcu7t5v0__dffq_1
Xclkload7 clkload7/I clkload7/Z VDD VDD VSS VSS gf180mcu_fd_sc_mcu7t5v0__clkbuf_2
X_2808_ _3959_/Q _3901_/Q _2815_/B VDD VDD VSS VSS gf180mcu_fd_sc_mcu7t5v0__nand2_1
X_3788_ _3788_/D clkload4/I _3788_/Q VDD VDD VSS VSS gf180mcu_fd_sc_mcu7t5v0__dffq_1
X_2739_ _2760_/C _2738_/Z _3891_/D VDD VDD VSS VSS gf180mcu_fd_sc_mcu7t5v0__nor2_1
XFILLER_120_317 VDD VDD VSS VSS gf180mcu_fd_sc_mcu7t5v0__fillcap_8
XFILLER_115_88 VDD VDD VSS VSS gf180mcu_fd_sc_mcu7t5v0__fill_2
XFILLER_86_242 VDD VDD VSS VSS gf180mcu_fd_sc_mcu7t5v0__fill_2
XFILLER_91_69 VDD VDD VSS VSS gf180mcu_fd_sc_mcu7t5v0__fill_1
XFILLER_24_85 VDD VDD VSS VSS gf180mcu_fd_sc_mcu7t5v0__fill_2
XFILLER_10_253 VDD VDD VSS VSS gf180mcu_fd_sc_mcu7t5v0__fill_2
XFILLER_6_257 VDD VDD VSS VSS gf180mcu_fd_sc_mcu7t5v0__fill_1
XFILLER_40_62 VDD VDD VSS VSS gf180mcu_fd_sc_mcu7t5v0__fillcap_4
XFILLER_108_185 VDD VDD VSS VSS gf180mcu_fd_sc_mcu7t5v0__fillcap_4
XFILLER_1_56 VDD VDD VSS VSS gf180mcu_fd_sc_mcu7t5v0__fillcap_8
XFILLER_77_275 VDD VDD VSS VSS gf180mcu_fd_sc_mcu7t5v0__fillcap_4
XTAP_TAPCELL_ROW_88_782 VDD VSS gf180mcu_fd_sc_mcu7t5v0__filltie
XFILLER_65_92 VDD VDD VSS VSS gf180mcu_fd_sc_mcu7t5v0__fill_2
X_1972_ _3973_/Q _3153_/A1 VDD VDD VSS VSS gf180mcu_fd_sc_mcu7t5v0__clkinv_1
XPHY_EDGE_ROW_112_Right_112 VDD VSS gf180mcu_fd_sc_mcu7t5v0__endcap
X_3711_ _3711_/A1 _3717_/A2 _3711_/B _4136_/D VDD VDD VSS VSS gf180mcu_fd_sc_mcu7t5v0__aoi21_1
X_3642_ _3787_/Q _3663_/A2 _3662_/B1 _3779_/Q _3645_/A1 VDD VDD VSS VSS gf180mcu_fd_sc_mcu7t5v0__aoi22_1
X_3573_ _3582_/A2 _3564_/Z _3573_/A3 _3574_/B VDD VDD VSS VSS gf180mcu_fd_sc_mcu7t5v0__nand3_1
XPHY_EDGE_ROW_49_Right_49 VDD VSS gf180mcu_fd_sc_mcu7t5v0__endcap
X_2524_ _3873_/Q _2543_/A2 _2524_/A3 _2527_/A1 VDD VDD VSS VSS gf180mcu_fd_sc_mcu7t5v0__nand3_1
XFILLER_114_177 VDD VDD VSS VSS gf180mcu_fd_sc_mcu7t5v0__fillcap_16
X_2455_ _3872_/Q _2525_/A2 _2517_/A2 _2455_/Z VDD VDD VSS VSS gf180mcu_fd_sc_mcu7t5v0__or3_1
X_2386_ _3871_/Q _2396_/A2 _2400_/B1 _3837_/Q _2387_/I VDD VDD VSS VSS gf180mcu_fd_sc_mcu7t5v0__aoi22_1
X_4125_ _4125_/D _4149_/CLK _4125_/Q VDD VDD VSS VSS gf180mcu_fd_sc_mcu7t5v0__dffq_1
XFILLER_45_18 VDD VDD VSS VSS gf180mcu_fd_sc_mcu7t5v0__fill_1
XFILLER_45_29 VDD VDD VSS VSS gf180mcu_fd_sc_mcu7t5v0__fillcap_16
XPHY_EDGE_ROW_58_Right_58 VDD VSS gf180mcu_fd_sc_mcu7t5v0__endcap
X_4056_ _4056_/D _4058_/CLK _4056_/Q VDD VDD VSS VSS gf180mcu_fd_sc_mcu7t5v0__dffq_1
X_3007_ _3007_/A1 _3007_/A2 _3007_/A3 _3007_/A4 _3007_/Z VDD VDD VSS VSS gf180mcu_fd_sc_mcu7t5v0__and4_1
XFILLER_83_278 VDD VDD VSS VSS gf180mcu_fd_sc_mcu7t5v0__fill_2
XFILLER_36_172 VDD VDD VSS VSS gf180mcu_fd_sc_mcu7t5v0__fill_2
XFILLER_51_120 VDD VDD VSS VSS gf180mcu_fd_sc_mcu7t5v0__fillcap_8
XFILLER_101_24 VDD VDD VSS VSS gf180mcu_fd_sc_mcu7t5v0__fill_1
XTAP_TAPCELL_ROW_106_886 VDD VSS gf180mcu_fd_sc_mcu7t5v0__filltie
X_3909_ _3909_/D _4034_/CLK _3909_/Q VDD VDD VSS VSS gf180mcu_fd_sc_mcu7t5v0__dffq_1
XPHY_EDGE_ROW_67_Right_67 VDD VSS gf180mcu_fd_sc_mcu7t5v0__endcap
XFILLER_19_117 VDD VDD VSS VSS gf180mcu_fd_sc_mcu7t5v0__fill_2
XPHY_EDGE_ROW_76_Right_76 VDD VSS gf180mcu_fd_sc_mcu7t5v0__endcap
XFILLER_19_139 VDD VDD VSS VSS gf180mcu_fd_sc_mcu7t5v0__fill_1
XFILLER_27_150 VDD VDD VSS VSS gf180mcu_fd_sc_mcu7t5v0__fill_2
XTAP_TAPCELL_ROW_85_763 VDD VSS gf180mcu_fd_sc_mcu7t5v0__filltie
XFILLER_42_164 VDD VDD VSS VSS gf180mcu_fd_sc_mcu7t5v0__fill_2
XFILLER_51_72 VDD VDD VSS VSS gf180mcu_fd_sc_mcu7t5v0__fillcap_8
XPHY_EDGE_ROW_85_Right_85 VDD VSS gf180mcu_fd_sc_mcu7t5v0__endcap
X_2240_ hold163/Z _2111_/Z _3746_/B _2241_/A2 VDD VDD VSS VSS gf180mcu_fd_sc_mcu7t5v0__oai21_1
XPHY_EDGE_ROW_94_Right_94 VDD VSS gf180mcu_fd_sc_mcu7t5v0__endcap
XFILLER_65_212 VDD VDD VSS VSS gf180mcu_fd_sc_mcu7t5v0__fill_2
X_2171_ _3777_/Q _2243_/A2 _3746_/B _2172_/A2 VDD VDD VSS VSS gf180mcu_fd_sc_mcu7t5v0__oai21_1
XFILLER_33_142 VDD VDD VSS VSS gf180mcu_fd_sc_mcu7t5v0__fill_1
XTAP_TAPCELL_ROW_16_351 VDD VSS gf180mcu_fd_sc_mcu7t5v0__filltie
XTAP_TAPCELL_ROW_91_799 VDD VSS gf180mcu_fd_sc_mcu7t5v0__filltie
X_1955_ _3990_/Q _3189_/A1 VDD VDD VSS VSS gf180mcu_fd_sc_mcu7t5v0__clkinv_1
X_1886_ _4127_/Q _3688_/A1 VDD VDD VSS VSS gf180mcu_fd_sc_mcu7t5v0__clkinv_1
X_3625_ _3793_/Q wire71/Z _3664_/B1 _3801_/Q _3627_/A2 VDD VDD VSS VSS gf180mcu_fd_sc_mcu7t5v0__aoi22_1
X_3556_ _4142_/Q _3538_/B _3579_/B VDD VDD VSS VSS gf180mcu_fd_sc_mcu7t5v0__nand2_1
X_2507_ _2380_/Z _2510_/A2 _2538_/A1 VDD VDD VSS VSS gf180mcu_fd_sc_mcu7t5v0__nand2_1
X_3487_ _4086_/Q _3481_/Z _3488_/B2 VDD VDD VSS VSS gf180mcu_fd_sc_mcu7t5v0__nand2_1
XTAP_TAPCELL_ROW_99_844 VDD VSS gf180mcu_fd_sc_mcu7t5v0__filltie
X_2438_ _3809_/Q _2451_/A2 _3256_/B _2439_/A2 VDD VDD VSS VSS gf180mcu_fd_sc_mcu7t5v0__oai21_1
X_2369_ _3827_/Q _3828_/Q _2372_/S _3828_/D VDD VDD VSS VSS gf180mcu_fd_sc_mcu7t5v0__mux2_2
X_4108_ _4108_/D clkload5/I _4108_/Q VDD VDD VSS VSS gf180mcu_fd_sc_mcu7t5v0__dffq_1
XFILLER_56_39 VDD VDD VSS VSS gf180mcu_fd_sc_mcu7t5v0__fill_1
XFILLER_56_267 VDD VDD VSS VSS gf180mcu_fd_sc_mcu7t5v0__fill_1
X_4039_ _4039_/D _4164_/CLK _4039_/Q VDD VDD VSS VSS gf180mcu_fd_sc_mcu7t5v0__dffq_1
XTAP_TAPCELL_ROW_39_487 VDD VSS gf180mcu_fd_sc_mcu7t5v0__filltie
XTAP_TAPCELL_ROW_82_744 VDD VSS gf180mcu_fd_sc_mcu7t5v0__filltie
XFILLER_72_49 VDD VDD VSS VSS gf180mcu_fd_sc_mcu7t5v0__fill_2
XTAP_TAPCELL_ROW_22_387 VDD VSS gf180mcu_fd_sc_mcu7t5v0__filltie
XFILLER_20_381 VDD VDD VSS VSS gf180mcu_fd_sc_mcu7t5v0__fillcap_4
XFILLER_47_212 VDD VDD VSS VSS gf180mcu_fd_sc_mcu7t5v0__fill_1
Xmax_cap73 _2987_/B1 _3156_/A1 VDD VDD VSS VSS gf180mcu_fd_sc_mcu7t5v0__buf_2
Xmax_cap62 _3012_/A2 _3088_/A1 VDD VDD VSS VSS gf180mcu_fd_sc_mcu7t5v0__buf_2
Xmax_cap40 _3283_/A2 _3291_/A2 VDD VDD VSS VSS gf180mcu_fd_sc_mcu7t5v0__buf_4
XFILLER_15_142 VDD VDD VSS VSS gf180mcu_fd_sc_mcu7t5v0__fillcap_8
XFILLER_15_131 VDD VDD VSS VSS gf180mcu_fd_sc_mcu7t5v0__fillcap_8
XFILLER_30_101 VDD VDD VSS VSS gf180mcu_fd_sc_mcu7t5v0__fillcap_4
XFILLER_70_270 VDD VDD VSS VSS gf180mcu_fd_sc_mcu7t5v0__fill_2
XTAP_TAPCELL_ROW_13_332 VDD VSS gf180mcu_fd_sc_mcu7t5v0__filltie
Xclkbuf_1_0__f__1532_ clkbuf_0__1532_/Z _3539_/A1 VDD VDD VSS VSS gf180mcu_fd_sc_mcu7t5v0__clkbuf_16
XFILLER_30_156 VDD VDD VSS VSS gf180mcu_fd_sc_mcu7t5v0__fillcap_4
XFILLER_7_22 VDD VDD VSS VSS gf180mcu_fd_sc_mcu7t5v0__fill_2
XFILLER_7_352 VDD VDD VSS VSS gf180mcu_fd_sc_mcu7t5v0__fillcap_64
Xtop_level_107 PAD_PDRV1[1] VDD VDD VSS VSS gf180mcu_fd_sc_mcu7t5v0__tieh
X_3410_ _4068_/Q _4067_/Q _3404_/Z _3410_/Z VDD VDD VSS VSS gf180mcu_fd_sc_mcu7t5v0__and3_1
X_3341_ _4054_/Q _3339_/Z _3343_/A2 VDD VDD VSS VSS gf180mcu_fd_sc_mcu7t5v0__nor2_1
X_3272_ _3272_/A1 _3274_/A2 _3272_/B _4029_/D VDD VDD VSS VSS gf180mcu_fd_sc_mcu7t5v0__aoi21_1
XFILLER_38_201 VDD VDD VSS VSS gf180mcu_fd_sc_mcu7t5v0__fill_1
X_2223_ hold186/Z _2111_/Z _3746_/B _2224_/A2 VDD VDD VSS VSS gf180mcu_fd_sc_mcu7t5v0__oai21_1
X_2154_ _2154_/A1 _2154_/A2 _3771_/D VDD VDD VSS VSS gf180mcu_fd_sc_mcu7t5v0__nor2_1
X_2085_ _3930_/Q _3929_/Q _3916_/Q _2087_/B VDD VDD VSS VSS gf180mcu_fd_sc_mcu7t5v0__oai21_1
XTAP_TAPCELL_ROW_36_468 VDD VSS gf180mcu_fd_sc_mcu7t5v0__filltie
XFILLER_21_134 VDD VDD VSS VSS gf180mcu_fd_sc_mcu7t5v0__fillcap_4
X_2987_ _4019_/Q _3241_/A1 _2987_/B1 _3979_/Q _2988_/A4 VDD VDD VSS VSS gf180mcu_fd_sc_mcu7t5v0__aoi22_1
X_1938_ _1938_/I _2628_/C VDD VDD VSS VSS gf180mcu_fd_sc_mcu7t5v0__clkinv_1
X_3608_ _3791_/Q wire71/Z _3664_/B1 _3799_/Q _3609_/A3 VDD VDD VSS VSS gf180mcu_fd_sc_mcu7t5v0__aoi22_1
XFILLER_115_294 VDD VDD VSS VSS gf180mcu_fd_sc_mcu7t5v0__fillcap_8
X_3539_ _3539_/A1 _3539_/A2 _4098_/D VDD VDD VSS VSS gf180mcu_fd_sc_mcu7t5v0__nor2_1
XFILLER_88_101 VDD VDD VSS VSS gf180mcu_fd_sc_mcu7t5v0__fillcap_4
XTAP_TAPCELL_ROW_27_413 VDD VSS gf180mcu_fd_sc_mcu7t5v0__filltie
XFILLER_12_156 VDD VDD VSS VSS gf180mcu_fd_sc_mcu7t5v0__fill_2
XTAP_TAPCELL_ROW_10_313 VDD VSS gf180mcu_fd_sc_mcu7t5v0__filltie
XFILLER_4_300 VDD VDD VSS VSS gf180mcu_fd_sc_mcu7t5v0__fillcap_8
XFILLER_35_226 VDD VDD VSS VSS gf180mcu_fd_sc_mcu7t5v0__fill_1
XFILLER_50_229 VDD VDD VSS VSS gf180mcu_fd_sc_mcu7t5v0__fillcap_4
X_2910_ _3151_/A1 _2910_/A2 _2910_/B _2922_/A2 VDD VDD VSS VSS gf180mcu_fd_sc_mcu7t5v0__oai21_1
XFILLER_90_376 VDD VDD VSS VSS gf180mcu_fd_sc_mcu7t5v0__fill_2
X_3890_ _3890_/D _4162_/CLK _3890_/Q VDD VDD VSS VSS gf180mcu_fd_sc_mcu7t5v0__dffq_1
XTAP_TAPCELL_ROW_33_449 VDD VSS gf180mcu_fd_sc_mcu7t5v0__filltie
X_2841_ _3964_/Q _3906_/Q _2863_/C VDD VDD VSS VSS gf180mcu_fd_sc_mcu7t5v0__nand2_1
X_2772_ _2772_/A1 _2772_/A2 _2773_/A2 VDD VDD VSS VSS gf180mcu_fd_sc_mcu7t5v0__xnor2_1
Xhold149 _3935_/Q _2010_/I VDD VDD VSS VSS gf180mcu_fd_sc_mcu7t5v0__dlyc_1
Xhold138 _3922_/Q hold138/Z VDD VDD VSS VSS gf180mcu_fd_sc_mcu7t5v0__dlyc_1
Xhold127 hold127/I _4165_/D VDD VDD VSS VSS gf180mcu_fd_sc_mcu7t5v0__dlyc_1
X_3324_ _4048_/Q _3321_/Z _3324_/Z VDD VDD VSS VSS gf180mcu_fd_sc_mcu7t5v0__and2_1
XFILLER_112_242 VDD VDD VSS VSS gf180mcu_fd_sc_mcu7t5v0__fill_2
X_3255_ _3255_/A1 _3257_/A2 _3255_/B _4021_/D VDD VDD VSS VSS gf180mcu_fd_sc_mcu7t5v0__aoi21_1
X_2206_ _4087_/Q _2248_/A2 _2208_/A1 VDD VDD VSS VSS gf180mcu_fd_sc_mcu7t5v0__nor2_1
XFILLER_85_126 VDD VDD VSS VSS gf180mcu_fd_sc_mcu7t5v0__fillcap_8
X_3186_ _3853_/Q wire44/Z wire81/I _3187_/B VDD VDD VSS VSS gf180mcu_fd_sc_mcu7t5v0__oai21_1
XFILLER_26_226 VDD VDD VSS VSS gf180mcu_fd_sc_mcu7t5v0__fillcap_4
X_2137_ _4047_/Q _2155_/A2 _2139_/A1 VDD VDD VSS VSS gf180mcu_fd_sc_mcu7t5v0__nor2_1
X_2068_ _3889_/Q _2577_/A2 VDD VDD VSS VSS gf180mcu_fd_sc_mcu7t5v0__clkinv_1
XFILLER_81_354 VDD VDD VSS VSS gf180mcu_fd_sc_mcu7t5v0__fill_1
XFILLER_1_347 VDD VDD VSS VSS gf180mcu_fd_sc_mcu7t5v0__fill_2
XFILLER_91_118 VDD VDD VSS VSS gf180mcu_fd_sc_mcu7t5v0__fill_1
XFILLER_94_47 VDD VDD VSS VSS gf180mcu_fd_sc_mcu7t5v0__fill_1
XFILLER_84_181 VDD VDD VSS VSS gf180mcu_fd_sc_mcu7t5v0__fillcap_8
XFILLER_84_170 VDD VDD VSS VSS gf180mcu_fd_sc_mcu7t5v0__fillcap_4
XTAP_TAPCELL_ROW_55_585 VDD VSS gf180mcu_fd_sc_mcu7t5v0__filltie
XTAP_TAPCELL_ROW_110_910 VDD VSS gf180mcu_fd_sc_mcu7t5v0__filltie
XFILLER_67_104 VDD VDD VSS VSS gf180mcu_fd_sc_mcu7t5v0__fillcap_16
XFILLER_95_402 VDD VDD VSS VSS gf180mcu_fd_sc_mcu7t5v0__fill_1
X_3040_ _3976_/Q _3156_/A1 _3040_/B1 _3931_/Q _3043_/A2 VDD VDD VSS VSS gf180mcu_fd_sc_mcu7t5v0__aoi22_1
XFILLER_48_384 VDD VDD VSS VSS gf180mcu_fd_sc_mcu7t5v0__fill_1
XTAP_TAPCELL_ROW_46_530 VDD VSS gf180mcu_fd_sc_mcu7t5v0__filltie
XFILLER_90_140 VDD VDD VSS VSS gf180mcu_fd_sc_mcu7t5v0__fill_2
X_3942_ _3942_/D _4169_/CLK _3942_/Q VDD VDD VSS VSS gf180mcu_fd_sc_mcu7t5v0__dffq_1
X_3873_ _3873_/D clkload5/I _3873_/Q VDD VDD VSS VSS gf180mcu_fd_sc_mcu7t5v0__dffq_1
X_2824_ _2823_/B _2824_/A2 _2824_/Z VDD VDD VSS VSS gf180mcu_fd_sc_mcu7t5v0__xor2_1
X_2755_ _3952_/Q _3894_/Q _2755_/Z VDD VDD VSS VSS gf180mcu_fd_sc_mcu7t5v0__xor2_1
XFILLER_117_356 VDD VDD VSS VSS gf180mcu_fd_sc_mcu7t5v0__fill_2
X_2686_ _2686_/A1 _2686_/A2 _2686_/A3 _2688_/A2 VDD VDD VSS VSS gf180mcu_fd_sc_mcu7t5v0__nor3_1
XFILLER_58_115 VDD VDD VSS VSS gf180mcu_fd_sc_mcu7t5v0__fill_1
X_3307_ _4043_/Q _3305_/Z _3309_/A2 VDD VDD VSS VSS gf180mcu_fd_sc_mcu7t5v0__nor2_1
XFILLER_98_251 VDD VDD VSS VSS gf180mcu_fd_sc_mcu7t5v0__fill_2
X_3238_ _3238_/A1 _3240_/A2 _3238_/B _4013_/D VDD VDD VSS VSS gf180mcu_fd_sc_mcu7t5v0__aoi21_1
XTAP_TAPCELL_ROW_69_666 VDD VSS gf180mcu_fd_sc_mcu7t5v0__filltie
XFILLER_73_107 VDD VDD VSS VSS gf180mcu_fd_sc_mcu7t5v0__fillcap_4
XFILLER_100_267 VDD VDD VSS VSS gf180mcu_fd_sc_mcu7t5v0__fillcap_4
X_3169_ _3288_/A1 _3170_/A2 _3256_/B _3170_/B VDD VDD VSS VSS gf180mcu_fd_sc_mcu7t5v0__oai21_1
XFILLER_66_181 VDD VDD VSS VSS gf180mcu_fd_sc_mcu7t5v0__fill_2
XFILLER_14_229 VDD VDD VSS VSS gf180mcu_fd_sc_mcu7t5v0__fill_1
XFILLER_54_387 VDD VDD VSS VSS gf180mcu_fd_sc_mcu7t5v0__fillcap_4
XFILLER_120_67 VDD VDD VSS VSS gf180mcu_fd_sc_mcu7t5v0__fillcap_8
XTAP_TAPCELL_ROW_52_566 VDD VSS gf180mcu_fd_sc_mcu7t5v0__filltie
XFILLER_13_54 VDD VDD VSS VSS gf180mcu_fd_sc_mcu7t5v0__fill_1
XFILLER_89_47 VDD VDD VSS VSS gf180mcu_fd_sc_mcu7t5v0__fill_1
XTAP_TAPCELL_ROW_43_511 VDD VSS gf180mcu_fd_sc_mcu7t5v0__filltie
XFILLER_9_244 VDD VDD VSS VSS gf180mcu_fd_sc_mcu7t5v0__fillcap_32
Xclkload25 _3537_/A2 clkload25/Z VDD VDD VSS VSS gf180mcu_fd_sc_mcu7t5v0__clkbuf_2
XFILLER_70_93 VDD VDD VSS VSS gf180mcu_fd_sc_mcu7t5v0__fill_1
Xclkload14 _4170_/CLK clkload14/Z VDD VDD VSS VSS gf180mcu_fd_sc_mcu7t5v0__clkbuf_2
X_2540_ _3876_/Q _2540_/A2 _2541_/B VDD VDD VSS VSS gf180mcu_fd_sc_mcu7t5v0__nor2_1
X_2471_ _3808_/Q _2495_/A2 _2495_/B1 _3856_/Q _2495_/C _2473_/A1 VDD VDD VSS VSS gf180mcu_fd_sc_mcu7t5v0__oai221_1
X_4141_ _4141_/D _4142_/CLK _4141_/Q VDD VDD VSS VSS gf180mcu_fd_sc_mcu7t5v0__dffq_1
X_4072_ _4072_/D _4079_/CLK _4072_/Q VDD VDD VSS VSS gf180mcu_fd_sc_mcu7t5v0__dffq_1
XFILLER_95_254 VDD VDD VSS VSS gf180mcu_fd_sc_mcu7t5v0__fillcap_4
XFILLER_48_170 VDD VDD VSS VSS gf180mcu_fd_sc_mcu7t5v0__fill_1
X_3023_ _3999_/Q _3207_/A1 _3030_/A1 VDD VDD VSS VSS gf180mcu_fd_sc_mcu7t5v0__nand2_1
XFILLER_95_298 VDD VDD VSS VSS gf180mcu_fd_sc_mcu7t5v0__fillcap_8
XTAP_TAPCELL_ROW_66_647 VDD VSS gf180mcu_fd_sc_mcu7t5v0__filltie
XFILLER_36_387 VDD VDD VSS VSS gf180mcu_fd_sc_mcu7t5v0__fill_2
X_3925_ _3925_/D clkload2/I _3925_/Q VDD VDD VSS VSS gf180mcu_fd_sc_mcu7t5v0__dffq_1
X_3856_ _3856_/D _4021_/CLK _3856_/Q VDD VDD VSS VSS gf180mcu_fd_sc_mcu7t5v0__dffq_1
Xclkload8 clkload8/I clkload8/Z VDD VDD VSS VSS gf180mcu_fd_sc_mcu7t5v0__clkbuf_4
X_2807_ _2750_/Z _2800_/Z _2807_/B wire31/I VDD VDD VSS VSS gf180mcu_fd_sc_mcu7t5v0__aoi21_1
X_3787_ _3787_/D clkload4/I _3787_/Q VDD VDD VSS VSS gf180mcu_fd_sc_mcu7t5v0__dffq_1
XFILLER_117_142 VDD VDD VSS VSS gf180mcu_fd_sc_mcu7t5v0__fillcap_4
X_2738_ _2738_/A1 _2738_/A2 _2738_/Z VDD VDD VSS VSS gf180mcu_fd_sc_mcu7t5v0__xor2_1
XFILLER_59_39 VDD VDD VSS VSS gf180mcu_fd_sc_mcu7t5v0__fill_2
X_2669_ _4031_/Q _2669_/A2 _2675_/A2 VDD VDD VSS VSS gf180mcu_fd_sc_mcu7t5v0__nand2_1
XFILLER_86_254 VDD VDD VSS VSS gf180mcu_fd_sc_mcu7t5v0__fillcap_16
XFILLER_39_170 VDD VDD VSS VSS gf180mcu_fd_sc_mcu7t5v0__fillcap_8
XFILLER_46_107 VDD VDD VSS VSS gf180mcu_fd_sc_mcu7t5v0__fill_2
XFILLER_74_416 VDD VDD VSS VSS gf180mcu_fd_sc_mcu7t5v0__fillcap_8
XFILLER_27_332 VDD VDD VSS VSS gf180mcu_fd_sc_mcu7t5v0__fillcap_4
XFILLER_54_173 VDD VDD VSS VSS gf180mcu_fd_sc_mcu7t5v0__fill_2
XPHY_EDGE_ROW_59_Left_181 VDD VSS gf180mcu_fd_sc_mcu7t5v0__endcap
XFILLER_10_243 VDD VDD VSS VSS gf180mcu_fd_sc_mcu7t5v0__fill_2
XFILLER_6_236 VDD VDD VSS VSS gf180mcu_fd_sc_mcu7t5v0__fill_1
XFILLER_40_74 VDD VDD VSS VSS gf180mcu_fd_sc_mcu7t5v0__fill_2
XPHY_EDGE_ROW_68_Left_190 VDD VSS gf180mcu_fd_sc_mcu7t5v0__endcap
XFILLER_49_61 VDD VDD VSS VSS gf180mcu_fd_sc_mcu7t5v0__fill_1
XFILLER_49_72 VDD VDD VSS VSS gf180mcu_fd_sc_mcu7t5v0__fillcap_8
XTAP_TAPCELL_ROW_5_280 VDD VSS gf180mcu_fd_sc_mcu7t5v0__filltie
XTAP_TAPCELL_ROW_88_783 VDD VSS gf180mcu_fd_sc_mcu7t5v0__filltie
XFILLER_1_68 VDD VDD VSS VSS gf180mcu_fd_sc_mcu7t5v0__fill_2
XTAP_TAPCELL_ROW_63_628 VDD VSS gf180mcu_fd_sc_mcu7t5v0__filltie
XFILLER_18_387 VDD VDD VSS VSS gf180mcu_fd_sc_mcu7t5v0__fillcap_32
XFILLER_33_313 VDD VDD VSS VSS gf180mcu_fd_sc_mcu7t5v0__fillcap_4
XFILLER_33_346 VDD VDD VSS VSS gf180mcu_fd_sc_mcu7t5v0__fillcap_4
X_1971_ _3974_/Q _3155_/A1 VDD VDD VSS VSS gf180mcu_fd_sc_mcu7t5v0__clkinv_1
X_3710_ wire90/Z _3717_/A2 wire81/Z _3711_/B VDD VDD VSS VSS gf180mcu_fd_sc_mcu7t5v0__oai21_1
X_3641_ _3731_/C _3641_/A2 _4118_/D VDD VDD VSS VSS gf180mcu_fd_sc_mcu7t5v0__nor2_1
X_3572_ _4141_/Q _3572_/A2 _3579_/B _3573_/A3 VDD VDD VSS VSS gf180mcu_fd_sc_mcu7t5v0__nor3_1
X_2523_ _2500_/Z _2522_/Z _2524_/A3 VDD VDD VSS VSS gf180mcu_fd_sc_mcu7t5v0__nand2_1
X_2454_ _3873_/Q _3874_/Q _2454_/A3 _2517_/A2 VDD VDD VSS VSS gf180mcu_fd_sc_mcu7t5v0__nand3_1
X_2385_ _2464_/A2 _2549_/A2 _2549_/B _4157_/Q wire51/I VDD VDD VSS VSS gf180mcu_fd_sc_mcu7t5v0__aoi211_2
X_4124_ _4124_/D _4149_/CLK _4124_/Q VDD VDD VSS VSS gf180mcu_fd_sc_mcu7t5v0__dffq_1
XFILLER_110_384 VDD VDD VSS VSS gf180mcu_fd_sc_mcu7t5v0__fill_1
XFILLER_28_107 VDD VDD VSS VSS gf180mcu_fd_sc_mcu7t5v0__fillcap_8
Xinput1 PAD_Y[0] input1/Z VDD VDD VSS VSS gf180mcu_fd_sc_mcu7t5v0__dlyb_1
X_4055_ _4055_/D _4058_/CLK _4055_/Q VDD VDD VSS VSS gf180mcu_fd_sc_mcu7t5v0__dffq_1
XFILLER_71_419 VDD VDD VSS VSS gf180mcu_fd_sc_mcu7t5v0__fill_1
X_3006_ _4037_/Q _3275_/A1 _3258_/A1 _4029_/Q _3007_/A4 VDD VDD VSS VSS gf180mcu_fd_sc_mcu7t5v0__aoi22_1
XTAP_TAPCELL_ROW_106_887 VDD VSS gf180mcu_fd_sc_mcu7t5v0__filltie
XFILLER_61_18 VDD VDD VSS VSS gf180mcu_fd_sc_mcu7t5v0__fill_2
X_3908_ _3908_/D _4034_/CLK _3908_/Q VDD VDD VSS VSS gf180mcu_fd_sc_mcu7t5v0__dffq_1
X_3839_ _3839_/D clkload3/I _3839_/Q VDD VDD VSS VSS gf180mcu_fd_sc_mcu7t5v0__dffq_1
XFILLER_120_104 VDD VDD VSS VSS gf180mcu_fd_sc_mcu7t5v0__fill_1
XFILLER_120_115 VDD VDD VSS VSS gf180mcu_fd_sc_mcu7t5v0__fillcap_4
XFILLER_86_37 VDD VDD VSS VSS gf180mcu_fd_sc_mcu7t5v0__fillcap_8
XFILLER_19_129 VDD VDD VSS VSS gf180mcu_fd_sc_mcu7t5v0__fillcap_8
XFILLER_47_416 VDD VDD VSS VSS gf180mcu_fd_sc_mcu7t5v0__fillcap_4
XFILLER_59_276 VDD VDD VSS VSS gf180mcu_fd_sc_mcu7t5v0__fillcap_4
XFILLER_74_257 VDD VDD VSS VSS gf180mcu_fd_sc_mcu7t5v0__fill_1
XTAP_TAPCELL_ROW_85_764 VDD VSS gf180mcu_fd_sc_mcu7t5v0__filltie
XFILLER_27_173 VDD VDD VSS VSS gf180mcu_fd_sc_mcu7t5v0__fill_1
Xclkbuf_0__1473__regs clkbuf_0__1473__regs/I clkbuf_0__1473__regs/Z VDD VDD VSS VSS
+ gf180mcu_fd_sc_mcu7t5v0__clkbuf_16
XFILLER_51_40 VDD VDD VSS VSS gf180mcu_fd_sc_mcu7t5v0__fill_1
X_2170_ hold154/Z _2242_/A2 _2172_/A1 VDD VDD VSS VSS gf180mcu_fd_sc_mcu7t5v0__nor2_1
XFILLER_65_235 VDD VDD VSS VSS gf180mcu_fd_sc_mcu7t5v0__fill_1
XFILLER_53_419 VDD VDD VSS VSS gf180mcu_fd_sc_mcu7t5v0__fill_1
XFILLER_65_279 VDD VDD VSS VSS gf180mcu_fd_sc_mcu7t5v0__fill_1
XTAP_TAPCELL_ROW_103_868 VDD VSS gf180mcu_fd_sc_mcu7t5v0__filltie
X_1954_ _3991_/Q _3192_/A1 VDD VDD VSS VSS gf180mcu_fd_sc_mcu7t5v0__clkinv_1
XFILLER_119_226 VDD VDD VSS VSS gf180mcu_fd_sc_mcu7t5v0__fillcap_4
X_3624_ _3785_/Q _3663_/A2 _3662_/B1 _3777_/Q _3627_/A1 VDD VDD VSS VSS gf180mcu_fd_sc_mcu7t5v0__aoi22_1
X_1885_ _4130_/Q _3696_/A1 VDD VDD VSS VSS gf180mcu_fd_sc_mcu7t5v0__clkinv_1
X_3555_ _3574_/A1 _4109_/Q _3572_/A2 VDD VDD VSS VSS gf180mcu_fd_sc_mcu7t5v0__nand2_1
X_2506_ _2380_/Z _2510_/A2 _2506_/Z VDD VDD VSS VSS gf180mcu_fd_sc_mcu7t5v0__and2_1
X_3486_ _4086_/Q _3481_/Z _3486_/Z VDD VDD VSS VSS gf180mcu_fd_sc_mcu7t5v0__and2_1
X_2437_ _3857_/Q _2430_/Z _2439_/A1 VDD VDD VSS VSS gf180mcu_fd_sc_mcu7t5v0__nor2_1
XTAP_TAPCELL_ROW_99_845 VDD VSS gf180mcu_fd_sc_mcu7t5v0__filltie
XFILLER_102_104 VDD VDD VSS VSS gf180mcu_fd_sc_mcu7t5v0__fill_1
X_2368_ _3826_/Q _3827_/Q _2373_/S _3827_/D VDD VDD VSS VSS gf180mcu_fd_sc_mcu7t5v0__mux2_2
XFILLER_29_416 VDD VDD VSS VSS gf180mcu_fd_sc_mcu7t5v0__fillcap_4
XFILLER_110_181 VDD VDD VSS VSS gf180mcu_fd_sc_mcu7t5v0__fillcap_16
X_4107_ _4107_/D clkload5/I _4107_/Q VDD VDD VSS VSS gf180mcu_fd_sc_mcu7t5v0__dffq_1
X_2299_ _3808_/Q _3809_/Q _2300_/S _3809_/D VDD VDD VSS VSS gf180mcu_fd_sc_mcu7t5v0__mux2_2
X_4038_ _4038_/D _4166_/CLK _4038_/Q VDD VDD VSS VSS gf180mcu_fd_sc_mcu7t5v0__dffq_1
XTAP_TAPCELL_ROW_39_488 VDD VSS gf180mcu_fd_sc_mcu7t5v0__filltie
XTAP_TAPCELL_ROW_82_745 VDD VSS gf180mcu_fd_sc_mcu7t5v0__filltie
XFILLER_79_305 VDD VDD VSS VSS gf180mcu_fd_sc_mcu7t5v0__fill_1
XFILLER_97_47 VDD VDD VSS VSS gf180mcu_fd_sc_mcu7t5v0__fill_2
XFILLER_47_246 VDD VDD VSS VSS gf180mcu_fd_sc_mcu7t5v0__fill_1
XFILLER_35_419 VDD VDD VSS VSS gf180mcu_fd_sc_mcu7t5v0__fill_1
Xmax_cap30 _2999_/A2 _3018_/A2 VDD VDD VSS VSS gf180mcu_fd_sc_mcu7t5v0__buf_1
Xmax_cap52 wire51/I _2400_/B1 VDD VDD VSS VSS gf180mcu_fd_sc_mcu7t5v0__buf_2
Xmax_cap63 _3015_/C1 _3139_/A1 VDD VDD VSS VSS gf180mcu_fd_sc_mcu7t5v0__buf_2
Xmax_cap41 _3268_/A2 _3274_/A2 VDD VDD VSS VSS gf180mcu_fd_sc_mcu7t5v0__buf_3
Xmax_cap74 _3014_/A2 _3207_/A1 VDD VDD VSS VSS gf180mcu_fd_sc_mcu7t5v0__buf_2
XTAP_TAPCELL_ROW_13_333 VDD VSS gf180mcu_fd_sc_mcu7t5v0__filltie
XFILLER_30_135 VDD VDD VSS VSS gf180mcu_fd_sc_mcu7t5v0__fillcap_4
XFILLER_62_50 VDD VDD VSS VSS gf180mcu_fd_sc_mcu7t5v0__fill_2
Xtop_level_108 i2c_scl_in_pu_control VDD VDD VSS VSS gf180mcu_fd_sc_mcu7t5v0__tieh
X_3340_ _3395_/A1 _3340_/A2 _3339_/Z _4053_/D VDD VDD VSS VSS gf180mcu_fd_sc_mcu7t5v0__nor3_1
XFILLER_112_424 VDD VDD VSS VSS gf180mcu_fd_sc_mcu7t5v0__fill_2
XFILLER_97_102 VDD VDD VSS VSS gf180mcu_fd_sc_mcu7t5v0__fillcap_8
X_3271_ _3288_/A1 _3274_/A2 wire81/Z _3272_/B VDD VDD VSS VSS gf180mcu_fd_sc_mcu7t5v0__oai21_1
XFILLER_97_135 VDD VDD VSS VSS gf180mcu_fd_sc_mcu7t5v0__fill_1
X_2222_ _4093_/Q _2248_/A2 _2224_/A1 VDD VDD VSS VSS gf180mcu_fd_sc_mcu7t5v0__nor2_1
XTAP_TAPCELL_ROW_96_826 VDD VSS gf180mcu_fd_sc_mcu7t5v0__filltie
XFILLER_78_382 VDD VDD VSS VSS gf180mcu_fd_sc_mcu7t5v0__fill_2
X_2153_ _3771_/Q _2243_/A2 _3746_/B _2154_/A2 VDD VDD VSS VSS gf180mcu_fd_sc_mcu7t5v0__oai21_1
XFILLER_26_419 VDD VDD VSS VSS gf180mcu_fd_sc_mcu7t5v0__fillcap_4
XFILLER_93_352 VDD VDD VSS VSS gf180mcu_fd_sc_mcu7t5v0__fill_1
XFILLER_53_238 VDD VDD VSS VSS gf180mcu_fd_sc_mcu7t5v0__fill_1
X_2084_ _3087_/A1 _3068_/A1 _2084_/B _4166_/D VDD VDD VSS VSS gf180mcu_fd_sc_mcu7t5v0__oai21_1
XTAP_TAPCELL_ROW_36_469 VDD VSS gf180mcu_fd_sc_mcu7t5v0__filltie
X_2986_ _4035_/Q _3027_/C1 _3105_/A1 _3955_/Q _2988_/A3 VDD VDD VSS VSS gf180mcu_fd_sc_mcu7t5v0__aoi22_1
X_1937_ _4008_/Q _3228_/A1 VDD VDD VSS VSS gf180mcu_fd_sc_mcu7t5v0__clkinv_1
X_3607_ _3783_/Q _3663_/A2 _3662_/B1 _3775_/Q _3609_/A2 VDD VDD VSS VSS gf180mcu_fd_sc_mcu7t5v0__aoi22_1
X_3538_ _4098_/Q _3538_/A2 _3538_/B _3539_/A2 VDD VDD VSS VSS gf180mcu_fd_sc_mcu7t5v0__oai21_1
XFILLER_107_57 VDD VDD VSS VSS gf180mcu_fd_sc_mcu7t5v0__fill_1
X_3469_ _3552_/C _3469_/A2 _4081_/D VDD VDD VSS VSS gf180mcu_fd_sc_mcu7t5v0__nor2_1
XFILLER_29_268 VDD VDD VSS VSS gf180mcu_fd_sc_mcu7t5v0__fill_2
XTAP_TAPCELL_ROW_27_414 VDD VSS gf180mcu_fd_sc_mcu7t5v0__filltie
XFILLER_16_43 VDD VDD VSS VSS gf180mcu_fd_sc_mcu7t5v0__fill_1
XFILLER_44_249 VDD VDD VSS VSS gf180mcu_fd_sc_mcu7t5v0__fill_1
XFILLER_12_102 VDD VDD VSS VSS gf180mcu_fd_sc_mcu7t5v0__fill_2
XFILLER_12_146 VDD VDD VSS VSS gf180mcu_fd_sc_mcu7t5v0__fill_2
XTAP_TAPCELL_ROW_10_314 VDD VSS gf180mcu_fd_sc_mcu7t5v0__filltie
XFILLER_4_312 VDD VDD VSS VSS gf180mcu_fd_sc_mcu7t5v0__fill_2
XFILLER_121_210 VDD VDD VSS VSS gf180mcu_fd_sc_mcu7t5v0__fill_2
XFILLER_121_276 VDD VDD VSS VSS gf180mcu_fd_sc_mcu7t5v0__fill_1
XFILLER_94_116 VDD VDD VSS VSS gf180mcu_fd_sc_mcu7t5v0__fill_1
Xclkbuf_leaf_20_ext_clk_in clkbuf_leaf_1_ext_clk_in/I clkload9/I VDD VDD VSS VSS gf180mcu_fd_sc_mcu7t5v0__clkbuf_8
XTAP_TAPCELL_ROW_113_930 VDD VSS gf180mcu_fd_sc_mcu7t5v0__filltie
XFILLER_31_422 VDD VDD VSS VSS gf180mcu_fd_sc_mcu7t5v0__fillcap_4
XFILLER_43_282 VDD VDD VSS VSS gf180mcu_fd_sc_mcu7t5v0__fill_2
XFILLER_73_93 VDD VDD VSS VSS gf180mcu_fd_sc_mcu7t5v0__fill_2
X_2840_ _2929_/A1 _2840_/A2 _3905_/D VDD VDD VSS VSS gf180mcu_fd_sc_mcu7t5v0__nor2_1
X_2771_ _3953_/Q _3895_/Q _2771_/B _2772_/A2 VDD VDD VSS VSS gf180mcu_fd_sc_mcu7t5v0__aoi21_1
XPHY_EDGE_ROW_9_Right_9 VDD VSS gf180mcu_fd_sc_mcu7t5v0__endcap
Xhold128 _3820_/Q hold128/Z VDD VDD VSS VSS gf180mcu_fd_sc_mcu7t5v0__dlyc_1
Xhold139 _4144_/Q hold139/Z VDD VDD VSS VSS gf180mcu_fd_sc_mcu7t5v0__dlyc_1
X_3323_ _4048_/Q _3321_/Z _3325_/A2 VDD VDD VSS VSS gf180mcu_fd_sc_mcu7t5v0__nor2_1
XFILLER_112_221 VDD VDD VSS VSS gf180mcu_fd_sc_mcu7t5v0__fill_1
XPHY_EDGE_ROW_13_Left_135 VDD VSS gf180mcu_fd_sc_mcu7t5v0__endcap
X_3254_ _3288_/A1 _3257_/A2 _3256_/B _3255_/B VDD VDD VSS VSS gf180mcu_fd_sc_mcu7t5v0__oai21_1
XFILLER_100_405 VDD VDD VSS VSS gf180mcu_fd_sc_mcu7t5v0__fill_1
XPHY_EDGE_ROW_107_Right_107 VDD VSS gf180mcu_fd_sc_mcu7t5v0__endcap
X_2205_ _2205_/A1 _2205_/A2 _3788_/D VDD VDD VSS VSS gf180mcu_fd_sc_mcu7t5v0__nor2_1
XFILLER_85_138 VDD VDD VSS VSS gf180mcu_fd_sc_mcu7t5v0__fill_2
X_3185_ _3185_/A1 wire44/Z _3185_/B _3988_/D VDD VDD VSS VSS gf180mcu_fd_sc_mcu7t5v0__aoi21_1
X_2136_ _2136_/A1 _2136_/A2 _3765_/D VDD VDD VSS VSS gf180mcu_fd_sc_mcu7t5v0__nor2_1
X_2067_ _3890_/Q _2633_/C1 VDD VDD VSS VSS gf180mcu_fd_sc_mcu7t5v0__clkinv_1
XFILLER_41_208 VDD VDD VSS VSS gf180mcu_fd_sc_mcu7t5v0__fill_2
XPHY_EDGE_ROW_22_Left_144 VDD VSS gf180mcu_fd_sc_mcu7t5v0__endcap
XFILLER_34_282 VDD VDD VSS VSS gf180mcu_fd_sc_mcu7t5v0__fill_1
X_2969_ _3986_/Q _3173_/A1 _3060_/A1 _3936_/Q _2977_/A1 VDD VDD VSS VSS gf180mcu_fd_sc_mcu7t5v0__aoi22_1
XFILLER_89_422 VDD VDD VSS VSS gf180mcu_fd_sc_mcu7t5v0__fillcap_4
XPHY_EDGE_ROW_31_Left_153 VDD VSS gf180mcu_fd_sc_mcu7t5v0__endcap
XFILLER_76_127 VDD VDD VSS VSS gf180mcu_fd_sc_mcu7t5v0__fillcap_4
XFILLER_27_97 VDD VDD VSS VSS gf180mcu_fd_sc_mcu7t5v0__fillcap_8
XPHY_EDGE_ROW_40_Left_162 VDD VSS gf180mcu_fd_sc_mcu7t5v0__endcap
XFILLER_72_377 VDD VDD VSS VSS gf180mcu_fd_sc_mcu7t5v0__fill_2
XTAP_TAPCELL_ROW_110_911 VDD VSS gf180mcu_fd_sc_mcu7t5v0__filltie
XFILLER_13_422 VDD VDD VSS VSS gf180mcu_fd_sc_mcu7t5v0__fillcap_4
XFILLER_40_285 VDD VDD VSS VSS gf180mcu_fd_sc_mcu7t5v0__fill_1
XFILLER_67_138 VDD VDD VSS VSS gf180mcu_fd_sc_mcu7t5v0__fill_2
XTAP_TAPCELL_ROW_46_531 VDD VSS gf180mcu_fd_sc_mcu7t5v0__filltie
X_3941_ _3941_/D _4169_/CLK _3941_/Q VDD VDD VSS VSS gf180mcu_fd_sc_mcu7t5v0__dffq_1
X_3872_ _3872_/D clkload6/I _3872_/Q VDD VDD VSS VSS gf180mcu_fd_sc_mcu7t5v0__dffq_1
X_2823_ _2823_/A1 _2836_/B1 _2823_/B _2828_/B VDD VDD VSS VSS gf180mcu_fd_sc_mcu7t5v0__oai21_1
X_2754_ _2760_/C _2754_/A2 _3893_/D VDD VDD VSS VSS gf180mcu_fd_sc_mcu7t5v0__nor2_1
X_2685_ _2685_/I _2694_/C VDD VDD VSS VSS gf180mcu_fd_sc_mcu7t5v0__clkinv_1
X_3306_ _3363_/B _3306_/A2 _3305_/Z _4042_/D VDD VDD VSS VSS gf180mcu_fd_sc_mcu7t5v0__nor3_1
XFILLER_58_127 VDD VDD VSS VSS gf180mcu_fd_sc_mcu7t5v0__fill_2
X_3237_ _3288_/A1 _3240_/A2 wire81/I _3238_/B VDD VDD VSS VSS gf180mcu_fd_sc_mcu7t5v0__oai21_1
XTAP_TAPCELL_ROW_69_667 VDD VSS gf180mcu_fd_sc_mcu7t5v0__filltie
X_3168_ _3168_/A1 _3172_/A2 _3168_/B _3980_/D VDD VDD VSS VSS gf180mcu_fd_sc_mcu7t5v0__aoi21_1
X_2119_ hold148/Z _2155_/A2 _2121_/A1 VDD VDD VSS VSS gf180mcu_fd_sc_mcu7t5v0__nor2_1
X_3099_ _3852_/Q _3104_/A2 wire81/I _3100_/B VDD VDD VSS VSS gf180mcu_fd_sc_mcu7t5v0__oai21_1
XFILLER_22_252 VDD VDD VSS VSS gf180mcu_fd_sc_mcu7t5v0__fillcap_16
XTAP_TAPCELL_ROW_52_567 VDD VSS gf180mcu_fd_sc_mcu7t5v0__filltie
XFILLER_22_274 VDD VDD VSS VSS gf180mcu_fd_sc_mcu7t5v0__fill_1
XFILLER_10_425 VDD VDD VSS VSS gf180mcu_fd_sc_mcu7t5v0__fill_1
XFILLER_13_44 VDD VDD VSS VSS gf180mcu_fd_sc_mcu7t5v0__fillcap_4
XFILLER_1_112 VDD VDD VSS VSS gf180mcu_fd_sc_mcu7t5v0__fillcap_4
XFILLER_1_178 VDD VDD VSS VSS gf180mcu_fd_sc_mcu7t5v0__fillcap_8
XFILLER_49_138 VDD VDD VSS VSS gf180mcu_fd_sc_mcu7t5v0__fill_2
XFILLER_38_52 VDD VDD VSS VSS gf180mcu_fd_sc_mcu7t5v0__fill_2
XFILLER_45_311 VDD VDD VSS VSS gf180mcu_fd_sc_mcu7t5v0__fill_2
XTAP_TAPCELL_ROW_43_512 VDD VSS gf180mcu_fd_sc_mcu7t5v0__filltie
XFILLER_13_252 VDD VDD VSS VSS gf180mcu_fd_sc_mcu7t5v0__fill_1
XFILLER_13_241 VDD VDD VSS VSS gf180mcu_fd_sc_mcu7t5v0__fill_1
XFILLER_13_274 VDD VDD VSS VSS gf180mcu_fd_sc_mcu7t5v0__fill_1
XFILLER_9_212 VDD VDD VSS VSS gf180mcu_fd_sc_mcu7t5v0__fill_2
Xclkload15 _4034_/CLK clkload15/ZN VDD VDD VSS VSS gf180mcu_fd_sc_mcu7t5v0__inv_3
Xclkload26 _3540_/A2 clkload26/Z VDD VDD VSS VSS gf180mcu_fd_sc_mcu7t5v0__clkbuf_2
XFILLER_114_305 VDD VDD VSS VSS gf180mcu_fd_sc_mcu7t5v0__fill_2
X_2470_ _2470_/A1 _2489_/C _2470_/B _3863_/D VDD VDD VSS VSS gf180mcu_fd_sc_mcu7t5v0__aoi21_1
XFILLER_55_6 VDD VDD VSS VSS gf180mcu_fd_sc_mcu7t5v0__fill_2
X_4140_ _4140_/D _4142_/CLK _4140_/Q VDD VDD VSS VSS gf180mcu_fd_sc_mcu7t5v0__dffq_1
XFILLER_68_425 VDD VDD VSS VSS gf180mcu_fd_sc_mcu7t5v0__fill_1
X_4071_ _4071_/D _4079_/CLK _4071_/Q VDD VDD VSS VSS gf180mcu_fd_sc_mcu7t5v0__dffq_1
X_3022_ _3838_/Q _3837_/Q _3022_/A3 _3049_/B1 VDD VDD VSS VSS gf180mcu_fd_sc_mcu7t5v0__nor3_1
XFILLER_95_91 VDD VDD VSS VSS gf180mcu_fd_sc_mcu7t5v0__fill_2
XTAP_TAPCELL_ROW_66_648 VDD VSS gf180mcu_fd_sc_mcu7t5v0__filltie
X_3924_ _3924_/D clkload2/I _3924_/Q VDD VDD VSS VSS gf180mcu_fd_sc_mcu7t5v0__dffq_1
Xclkload9 clkload9/I clkload9/Z VDD VDD VSS VSS gf180mcu_fd_sc_mcu7t5v0__clkbuf_4
X_3855_ _3855_/D _4021_/CLK _3855_/Q VDD VDD VSS VSS gf180mcu_fd_sc_mcu7t5v0__dffq_1
X_2806_ _2806_/A1 _2806_/A2 _2806_/A3 _2806_/A4 _2807_/B VDD VDD VSS VSS gf180mcu_fd_sc_mcu7t5v0__nand4_1
X_3786_ _3786_/D clkload4/I _3786_/Q VDD VDD VSS VSS gf180mcu_fd_sc_mcu7t5v0__dffq_1
X_2737_ _2743_/A1 _2737_/A2 _2738_/A2 _2743_/A2 VDD VDD VSS VSS gf180mcu_fd_sc_mcu7t5v0__nand3_1
X_2668_ _4036_/Q _2910_/A2 _2695_/B VDD VDD VSS VSS gf180mcu_fd_sc_mcu7t5v0__nor2_1
X_2599_ _2599_/A1 _2599_/A2 _2603_/A2 VDD VDD VSS VSS gf180mcu_fd_sc_mcu7t5v0__nor2_1
XFILLER_86_244 VDD VDD VSS VSS gf180mcu_fd_sc_mcu7t5v0__fill_1
XFILLER_86_299 VDD VDD VSS VSS gf180mcu_fd_sc_mcu7t5v0__fill_2
XFILLER_54_141 VDD VDD VSS VSS gf180mcu_fd_sc_mcu7t5v0__fill_1
XFILLER_54_163 VDD VDD VSS VSS gf180mcu_fd_sc_mcu7t5v0__fill_1
XFILLER_24_87 VDD VDD VSS VSS gf180mcu_fd_sc_mcu7t5v0__fill_1
XFILLER_10_255 VDD VDD VSS VSS gf180mcu_fd_sc_mcu7t5v0__fill_1
XTAP_TAPCELL_ROW_5_281 VDD VSS gf180mcu_fd_sc_mcu7t5v0__filltie
XFILLER_45_130 VDD VDD VSS VSS gf180mcu_fd_sc_mcu7t5v0__fillcap_8
XFILLER_65_72 VDD VDD VSS VSS gf180mcu_fd_sc_mcu7t5v0__fillcap_16
XFILLER_45_196 VDD VDD VSS VSS gf180mcu_fd_sc_mcu7t5v0__fill_2
XTAP_TAPCELL_ROW_63_629 VDD VSS gf180mcu_fd_sc_mcu7t5v0__filltie
X_1970_ _1970_/I _3158_/A1 VDD VDD VSS VSS gf180mcu_fd_sc_mcu7t5v0__clkinv_1
XFILLER_60_177 VDD VDD VSS VSS gf180mcu_fd_sc_mcu7t5v0__fillcap_4
XFILLER_81_93 VDD VDD VSS VSS gf180mcu_fd_sc_mcu7t5v0__fill_2
X_3640_ hold182/Z _3669_/A2 _3650_/B1 _3640_/B2 _3641_/A2 VDD VDD VSS VSS gf180mcu_fd_sc_mcu7t5v0__aoi22_1
X_3571_ _3571_/A1 _3574_/A2 _4109_/D VDD VDD VSS VSS gf180mcu_fd_sc_mcu7t5v0__nor2_1
X_2522_ _3873_/Q _2529_/A3 _2510_/B _2522_/Z VDD VDD VSS VSS gf180mcu_fd_sc_mcu7t5v0__and3_1
X_2453_ _2461_/A2 _2529_/A3 _2453_/B _2475_/A2 VDD VDD VSS VSS gf180mcu_fd_sc_mcu7t5v0__aoi21_1
XFILLER_46_2 VDD VDD VSS VSS gf180mcu_fd_sc_mcu7t5v0__fill_2
X_2384_ _3881_/Q _2380_/Z _2549_/B VDD VDD VSS VSS gf180mcu_fd_sc_mcu7t5v0__nor2_1
X_4123_ _4123_/D _4142_/CLK _4123_/Q VDD VDD VSS VSS gf180mcu_fd_sc_mcu7t5v0__dffq_1
Xinput2 PAD_Y[1] input2/Z VDD VDD VSS VSS gf180mcu_fd_sc_mcu7t5v0__dlyb_1
X_4054_ _4054_/D _4058_/CLK _4054_/Q VDD VDD VSS VSS gf180mcu_fd_sc_mcu7t5v0__dffq_1
X_3005_ _4013_/Q _3005_/A2 _3241_/A1 _4021_/Q _3008_/A2 VDD VDD VSS VSS gf180mcu_fd_sc_mcu7t5v0__aoi22_1
XFILLER_24_314 VDD VDD VSS VSS gf180mcu_fd_sc_mcu7t5v0__fill_1
XFILLER_36_174 VDD VDD VSS VSS gf180mcu_fd_sc_mcu7t5v0__fill_1
XTAP_TAPCELL_ROW_106_888 VDD VSS gf180mcu_fd_sc_mcu7t5v0__filltie
X_3907_ _3907_/D _4155_/CLK _3907_/Q VDD VDD VSS VSS gf180mcu_fd_sc_mcu7t5v0__dffq_1
X_3838_ _3838_/D clkload7/I _3838_/Q VDD VDD VSS VSS gf180mcu_fd_sc_mcu7t5v0__dffq_1
X_3769_ _3769_/D _4052_/CLK _3769_/Q VDD VDD VSS VSS gf180mcu_fd_sc_mcu7t5v0__dffq_1
XPHY_EDGE_ROW_5_Left_127 VDD VSS gf180mcu_fd_sc_mcu7t5v0__endcap
XFILLER_86_49 VDD VDD VSS VSS gf180mcu_fd_sc_mcu7t5v0__fillcap_4
XFILLER_101_352 VDD VDD VSS VSS gf180mcu_fd_sc_mcu7t5v0__fillcap_4
XFILLER_74_236 VDD VDD VSS VSS gf180mcu_fd_sc_mcu7t5v0__fillcap_8
XFILLER_27_152 VDD VDD VSS VSS gf180mcu_fd_sc_mcu7t5v0__fill_1
XTAP_TAPCELL_ROW_2_262 VDD VSS gf180mcu_fd_sc_mcu7t5v0__filltie
XTAP_TAPCELL_ROW_85_765 VDD VSS gf180mcu_fd_sc_mcu7t5v0__filltie
XFILLER_15_347 VDD VDD VSS VSS gf180mcu_fd_sc_mcu7t5v0__fill_2
XFILLER_35_64 VDD VDD VSS VSS gf180mcu_fd_sc_mcu7t5v0__fillcap_4
XFILLER_30_317 VDD VDD VSS VSS gf180mcu_fd_sc_mcu7t5v0__fill_2
XFILLER_42_166 VDD VDD VSS VSS gf180mcu_fd_sc_mcu7t5v0__fill_1
XFILLER_111_138 VDD VDD VSS VSS gf180mcu_fd_sc_mcu7t5v0__fill_2
XTAP_TAPCELL_ROW_76_710 VDD VSS gf180mcu_fd_sc_mcu7t5v0__filltie
XFILLER_76_93 VDD VDD VSS VSS gf180mcu_fd_sc_mcu7t5v0__fill_2
XFILLER_18_141 VDD VDD VSS VSS gf180mcu_fd_sc_mcu7t5v0__fillcap_4
XFILLER_18_174 VDD VDD VSS VSS gf180mcu_fd_sc_mcu7t5v0__fill_1
XTAP_TAPCELL_ROW_103_869 VDD VSS gf180mcu_fd_sc_mcu7t5v0__filltie
XFILLER_14_380 VDD VDD VSS VSS gf180mcu_fd_sc_mcu7t5v0__fillcap_4
X_1953_ _3992_/Q _3194_/A1 VDD VDD VSS VSS gf180mcu_fd_sc_mcu7t5v0__clkinv_1
X_1884_ _4131_/Q _3698_/A1 VDD VDD VSS VSS gf180mcu_fd_sc_mcu7t5v0__clkinv_1
X_3623_ _3731_/C _3623_/A2 _4116_/D VDD VDD VSS VSS gf180mcu_fd_sc_mcu7t5v0__nor2_1
XFILLER_115_422 VDD VDD VSS VSS gf180mcu_fd_sc_mcu7t5v0__fillcap_4
XFILLER_115_411 VDD VDD VSS VSS gf180mcu_fd_sc_mcu7t5v0__fillcap_8
X_3554_ _4108_/Q _4107_/Q _3554_/Z VDD VDD VSS VSS gf180mcu_fd_sc_mcu7t5v0__or2_1
X_2505_ _3818_/Q _2505_/A2 _2427_/Z _2510_/A2 VDD VDD VSS VSS gf180mcu_fd_sc_mcu7t5v0__nor3_1
X_3485_ _3552_/C _3485_/A2 _4085_/D VDD VDD VSS VSS gf180mcu_fd_sc_mcu7t5v0__nor2_1
X_2436_ _3256_/B _2436_/A2 _2436_/A3 _3856_/D VDD VDD VSS VSS gf180mcu_fd_sc_mcu7t5v0__nand3_1
XTAP_TAPCELL_ROW_99_846 VDD VSS gf180mcu_fd_sc_mcu7t5v0__filltie
X_2367_ _2367_/A1 _2372_/S _2367_/B _3826_/D VDD VDD VSS VSS gf180mcu_fd_sc_mcu7t5v0__oai21_1
X_4106_ _4106_/D _4162_/CLK _4106_/Q VDD VDD VSS VSS gf180mcu_fd_sc_mcu7t5v0__dffq_1
X_2298_ _2457_/A1 _2300_/S _2298_/B _3808_/D VDD VDD VSS VSS gf180mcu_fd_sc_mcu7t5v0__oai21_1
XFILLER_56_247 VDD VDD VSS VSS gf180mcu_fd_sc_mcu7t5v0__fillcap_8
X_4037_ _4037_/D _4166_/CLK _4037_/Q VDD VDD VSS VSS gf180mcu_fd_sc_mcu7t5v0__dffq_1
XTAP_TAPCELL_ROW_39_489 VDD VSS gf180mcu_fd_sc_mcu7t5v0__filltie
XFILLER_64_291 VDD VDD VSS VSS gf180mcu_fd_sc_mcu7t5v0__fill_2
XTAP_TAPCELL_ROW_82_746 VDD VSS gf180mcu_fd_sc_mcu7t5v0__filltie
XFILLER_24_177 VDD VDD VSS VSS gf180mcu_fd_sc_mcu7t5v0__fillcap_4
XTAP_TAPCELL_ROW_90_790 VDD VSS gf180mcu_fd_sc_mcu7t5v0__filltie
XFILLER_97_15 VDD VDD VSS VSS gf180mcu_fd_sc_mcu7t5v0__fill_2
Xclkbuf_leaf_10_ext_clk_in clkload0/I _4058_/CLK VDD VDD VSS VSS gf180mcu_fd_sc_mcu7t5v0__clkbuf_8
XFILLER_87_372 VDD VDD VSS VSS gf180mcu_fd_sc_mcu7t5v0__fillcap_4
XFILLER_46_30 VDD VDD VSS VSS gf180mcu_fd_sc_mcu7t5v0__fillcap_4
Xmax_cap42 _3243_/A2 _3257_/A2 VDD VDD VSS VSS gf180mcu_fd_sc_mcu7t5v0__buf_3
XFILLER_62_239 VDD VDD VSS VSS gf180mcu_fd_sc_mcu7t5v0__fillcap_4
Xmax_cap64 _3036_/B1 _3122_/A1 VDD VDD VSS VSS gf180mcu_fd_sc_mcu7t5v0__buf_2
Xmax_cap53 _3726_/A1 _3723_/A2 VDD VDD VSS VSS gf180mcu_fd_sc_mcu7t5v0__buf_2
Xmax_cap86 _3854_/Q _3290_/A1 VDD VDD VSS VSS gf180mcu_fd_sc_mcu7t5v0__buf_4
Xmax_cap75 _3037_/C2 _3173_/A1 VDD VDD VSS VSS gf180mcu_fd_sc_mcu7t5v0__buf_2
XFILLER_15_155 VDD VDD VSS VSS gf180mcu_fd_sc_mcu7t5v0__fillcap_8
XFILLER_7_24 VDD VDD VSS VSS gf180mcu_fd_sc_mcu7t5v0__fill_1
XFILLER_7_68 VDD VDD VSS VSS gf180mcu_fd_sc_mcu7t5v0__fill_2
Xtop_level_109 i2c_sda_out_cs_control VDD VDD VSS VSS gf180mcu_fd_sc_mcu7t5v0__tieh
X_3270_ _3270_/A1 _3274_/A2 _3270_/B _4028_/D VDD VDD VSS VSS gf180mcu_fd_sc_mcu7t5v0__aoi21_1
XFILLER_97_125 VDD VDD VSS VSS gf180mcu_fd_sc_mcu7t5v0__fillcap_8
X_2221_ _2221_/A1 _2221_/A2 _3794_/D VDD VDD VSS VSS gf180mcu_fd_sc_mcu7t5v0__nor2_1
XTAP_TAPCELL_ROW_96_827 VDD VSS gf180mcu_fd_sc_mcu7t5v0__filltie
X_2152_ _4052_/Q _2155_/A2 _2154_/A1 VDD VDD VSS VSS gf180mcu_fd_sc_mcu7t5v0__nor2_1
X_2083_ _3068_/A1 hold187/Z _2084_/B VDD VDD VSS VSS gf180mcu_fd_sc_mcu7t5v0__nand2_1
XTAP_TAPCELL_ROW_116_950 VDD VSS gf180mcu_fd_sc_mcu7t5v0__filltie
XFILLER_93_386 VDD VDD VSS VSS gf180mcu_fd_sc_mcu7t5v0__fillcap_4
XFILLER_46_280 VDD VDD VSS VSS gf180mcu_fd_sc_mcu7t5v0__fill_2
X_2985_ _4011_/Q _3005_/A2 _3013_/B1 _3995_/Q _2985_/C _2988_/A2 VDD VDD VSS VSS gf180mcu_fd_sc_mcu7t5v0__aoi221_1
XPHY_EDGE_ROW_86_Left_208 VDD VSS gf180mcu_fd_sc_mcu7t5v0__endcap
X_1936_ _1936_/I _3230_/A1 VDD VDD VSS VSS gf180mcu_fd_sc_mcu7t5v0__clkinv_1
X_3606_ _3759_/Q _3662_/A2 _3663_/B1 _3767_/Q _3609_/A1 VDD VDD VSS VSS gf180mcu_fd_sc_mcu7t5v0__aoi22_1
X_3537_ _3549_/A1 _3537_/A2 _3537_/A3 _3537_/ZN VDD VDD VSS VSS gf180mcu_fd_sc_mcu7t5v0__nor3_1
XFILLER_107_47 VDD VDD VSS VSS gf180mcu_fd_sc_mcu7t5v0__fillcap_8
X_3468_ _4081_/Q _3479_/A2 _3549_/B _3467_/Z _3469_/A2 VDD VDD VSS VSS gf180mcu_fd_sc_mcu7t5v0__aoi22_1
XFILLER_88_158 VDD VDD VSS VSS gf180mcu_fd_sc_mcu7t5v0__fill_1
X_2419_ _2419_/I _3853_/D VDD VDD VSS VSS gf180mcu_fd_sc_mcu7t5v0__clkinv_1
XPHY_EDGE_ROW_95_Left_217 VDD VSS gf180mcu_fd_sc_mcu7t5v0__endcap
X_3399_ _3552_/C _3399_/A2 _3398_/Z _4064_/D VDD VDD VSS VSS gf180mcu_fd_sc_mcu7t5v0__nor3_1
XTAP_TAPCELL_ROW_27_415 VDD VSS gf180mcu_fd_sc_mcu7t5v0__filltie
XFILLER_37_291 VDD VDD VSS VSS gf180mcu_fd_sc_mcu7t5v0__fillcap_16
XFILLER_12_125 VDD VDD VSS VSS gf180mcu_fd_sc_mcu7t5v0__fillcap_4
XFILLER_8_107 VDD VDD VSS VSS gf180mcu_fd_sc_mcu7t5v0__fillcap_4
XTAP_TAPCELL_ROW_10_315 VDD VSS gf180mcu_fd_sc_mcu7t5v0__filltie
XFILLER_87_180 VDD VDD VSS VSS gf180mcu_fd_sc_mcu7t5v0__fill_1
XTAP_TAPCELL_ROW_93_808 VDD VSS gf180mcu_fd_sc_mcu7t5v0__filltie
XTAP_TAPCELL_ROW_113_931 VDD VSS gf180mcu_fd_sc_mcu7t5v0__filltie
XFILLER_73_72 VDD VDD VSS VSS gf180mcu_fd_sc_mcu7t5v0__fillcap_8
XFILLER_90_378 VDD VDD VSS VSS gf180mcu_fd_sc_mcu7t5v0__fill_1
X_2770_ _2779_/C _2776_/B _2772_/A1 VDD VDD VSS VSS gf180mcu_fd_sc_mcu7t5v0__nand2_1
Xhold129 _3879_/Q _2017_/I VDD VDD VSS VSS gf180mcu_fd_sc_mcu7t5v0__dlyc_1
XFILLER_98_423 VDD VDD VSS VSS gf180mcu_fd_sc_mcu7t5v0__fill_2
X_3322_ _3395_/A1 _3322_/A2 _3321_/Z _4047_/D VDD VDD VSS VSS gf180mcu_fd_sc_mcu7t5v0__nor3_1
XFILLER_112_255 VDD VDD VSS VSS gf180mcu_fd_sc_mcu7t5v0__fill_1
XFILLER_112_244 VDD VDD VSS VSS gf180mcu_fd_sc_mcu7t5v0__fill_1
X_3253_ _3253_/A1 _3257_/A2 _3253_/B _4020_/D VDD VDD VSS VSS gf180mcu_fd_sc_mcu7t5v0__aoi21_1
X_3184_ _3754_/I1 wire44/Z wire81/I _3185_/B VDD VDD VSS VSS gf180mcu_fd_sc_mcu7t5v0__oai21_1
X_2204_ _3788_/Q _2111_/Z _3746_/B _2205_/A2 VDD VDD VSS VSS gf180mcu_fd_sc_mcu7t5v0__oai21_1
X_2135_ _3765_/Q _2243_/A2 _3746_/B _2136_/A2 VDD VDD VSS VSS gf180mcu_fd_sc_mcu7t5v0__oai21_1
XFILLER_66_375 VDD VDD VSS VSS gf180mcu_fd_sc_mcu7t5v0__fill_1
X_2066_ _3891_/Q _2746_/A2 VDD VDD VSS VSS gf180mcu_fd_sc_mcu7t5v0__clkinv_1
XFILLER_22_423 VDD VDD VSS VSS gf180mcu_fd_sc_mcu7t5v0__fill_2
XFILLER_34_272 VDD VDD VSS VSS gf180mcu_fd_sc_mcu7t5v0__fill_2
X_2968_ _3731_/C _2968_/A2 _3919_/D VDD VDD VSS VSS gf180mcu_fd_sc_mcu7t5v0__nor2_1
X_1919_ _4026_/Q _3266_/A1 VDD VDD VSS VSS gf180mcu_fd_sc_mcu7t5v0__clkinv_1
X_2899_ _3149_/A1 _3913_/Q _2899_/Z VDD VDD VSS VSS gf180mcu_fd_sc_mcu7t5v0__xor2_1
XFILLER_1_349 VDD VDD VSS VSS gf180mcu_fd_sc_mcu7t5v0__fill_1
XFILLER_27_10 VDD VDD VSS VSS gf180mcu_fd_sc_mcu7t5v0__fill_1
XFILLER_72_312 VDD VDD VSS VSS gf180mcu_fd_sc_mcu7t5v0__fill_2
XTAP_TAPCELL_ROW_110_912 VDD VSS gf180mcu_fd_sc_mcu7t5v0__filltie
XFILLER_9_416 VDD VDD VSS VSS gf180mcu_fd_sc_mcu7t5v0__fillcap_4
Xclkbuf_leaf_0_ext_clk_in clkbuf_leaf_1_ext_clk_in/I clkload1/I VDD VDD VSS VSS gf180mcu_fd_sc_mcu7t5v0__clkbuf_8
XFILLER_108_90 VDD VDD VSS VSS gf180mcu_fd_sc_mcu7t5v0__fill_1
XFILLER_90_142 VDD VDD VSS VSS gf180mcu_fd_sc_mcu7t5v0__fill_1
X_3940_ _3940_/D _4170_/CLK _3940_/Q VDD VDD VSS VSS gf180mcu_fd_sc_mcu7t5v0__dffq_1
XFILLER_16_261 VDD VDD VSS VSS gf180mcu_fd_sc_mcu7t5v0__fillcap_4
XFILLER_90_197 VDD VDD VSS VSS gf180mcu_fd_sc_mcu7t5v0__fillcap_8
X_3871_ _3871_/D clkload5/I _3871_/Q VDD VDD VSS VSS gf180mcu_fd_sc_mcu7t5v0__dffq_1
X_2822_ _2823_/A1 _2836_/B1 _2824_/A2 VDD VDD VSS VSS gf180mcu_fd_sc_mcu7t5v0__nor2_1
X_2753_ _2750_/Z _2751_/Z _2754_/A2 VDD VDD VSS VSS gf180mcu_fd_sc_mcu7t5v0__xnor2_1
XFILLER_76_2 VDD VDD VSS VSS gf180mcu_fd_sc_mcu7t5v0__fill_2
X_2684_ _4035_/Q _2684_/A2 _2684_/B _2684_/C _2685_/I VDD VDD VSS VSS gf180mcu_fd_sc_mcu7t5v0__oai211_1
X_3305_ _4042_/Q _3302_/Z _3305_/Z VDD VDD VSS VSS gf180mcu_fd_sc_mcu7t5v0__and2_1
XFILLER_100_214 VDD VDD VSS VSS gf180mcu_fd_sc_mcu7t5v0__fill_2
X_3236_ _3236_/A1 _3240_/A2 _3236_/B _4012_/D VDD VDD VSS VSS gf180mcu_fd_sc_mcu7t5v0__aoi21_1
XTAP_TAPCELL_ROW_69_668 VDD VSS gf180mcu_fd_sc_mcu7t5v0__filltie
X_3167_ _3286_/A1 _3172_/A2 wire81/I _3168_/B VDD VDD VSS VSS gf180mcu_fd_sc_mcu7t5v0__oai21_1
X_3098_ _3098_/A1 _3104_/A2 _3098_/B _3947_/D VDD VDD VSS VSS gf180mcu_fd_sc_mcu7t5v0__aoi21_1
X_2118_ _2118_/A1 _2118_/A2 _3759_/D VDD VDD VSS VSS gf180mcu_fd_sc_mcu7t5v0__nor2_1
XFILLER_81_142 VDD VDD VSS VSS gf180mcu_fd_sc_mcu7t5v0__fill_1
X_2049_ _3911_/Q _2896_/A2 VDD VDD VSS VSS gf180mcu_fd_sc_mcu7t5v0__clkinv_1
XFILLER_120_25 VDD VDD VSS VSS gf180mcu_fd_sc_mcu7t5v0__fillcap_4
XFILLER_22_242 VDD VDD VSS VSS gf180mcu_fd_sc_mcu7t5v0__fill_2
XFILLER_22_231 VDD VDD VSS VSS gf180mcu_fd_sc_mcu7t5v0__fill_1
XFILLER_6_419 VDD VDD VSS VSS gf180mcu_fd_sc_mcu7t5v0__fillcap_4
XFILLER_38_86 VDD VDD VSS VSS gf180mcu_fd_sc_mcu7t5v0__fillcap_8
XTAP_TAPCELL_ROW_43_513 VDD VSS gf180mcu_fd_sc_mcu7t5v0__filltie
XFILLER_54_85 VDD VDD VSS VSS gf180mcu_fd_sc_mcu7t5v0__fillcap_8
Xclkload16 _4149_/CLK clkload16/ZN VDD VDD VSS VSS gf180mcu_fd_sc_mcu7t5v0__inv_3
Xclkload27 _3549_/B clkload27/ZN VDD VDD VSS VSS gf180mcu_fd_sc_mcu7t5v0__inv_4
XFILLER_114_317 VDD VDD VSS VSS gf180mcu_fd_sc_mcu7t5v0__fillcap_4
XFILLER_95_212 VDD VDD VSS VSS gf180mcu_fd_sc_mcu7t5v0__fillcap_16
X_4070_ _4070_/D _4079_/CLK _4070_/Q VDD VDD VSS VSS gf180mcu_fd_sc_mcu7t5v0__dffq_1
X_3021_ _3941_/Q _3083_/A1 _3032_/A1 VDD VDD VSS VSS gf180mcu_fd_sc_mcu7t5v0__nand2_1
XFILLER_36_312 VDD VDD VSS VSS gf180mcu_fd_sc_mcu7t5v0__fill_2
XTAP_TAPCELL_ROW_66_649 VDD VSS gf180mcu_fd_sc_mcu7t5v0__filltie
XFILLER_63_142 VDD VDD VSS VSS gf180mcu_fd_sc_mcu7t5v0__fill_2
X_3923_ _3923_/D clkload2/I _3923_/Q VDD VDD VSS VSS gf180mcu_fd_sc_mcu7t5v0__dffq_1
X_3854_ _3854_/D clkload6/I _3854_/Q VDD VDD VSS VSS gf180mcu_fd_sc_mcu7t5v0__dffq_1
X_2805_ _2779_/C _2805_/A2 _2805_/A3 _2806_/A4 VDD VDD VSS VSS gf180mcu_fd_sc_mcu7t5v0__nand3_1
X_3785_ _3785_/D _4058_/CLK _3785_/Q VDD VDD VSS VSS gf180mcu_fd_sc_mcu7t5v0__dffq_1
X_2736_ _2721_/Z _2749_/A3 _2736_/B _2738_/A2 VDD VDD VSS VSS gf180mcu_fd_sc_mcu7t5v0__oai21_1
XFILLER_117_155 VDD VDD VSS VSS gf180mcu_fd_sc_mcu7t5v0__fill_1
X_2667_ _4035_/Q _2684_/A2 _2695_/A1 VDD VDD VSS VSS gf180mcu_fd_sc_mcu7t5v0__nand2_1
XFILLER_105_328 VDD VDD VSS VSS gf180mcu_fd_sc_mcu7t5v0__fillcap_4
X_2598_ _3990_/Q _2640_/A2 _2598_/B _3989_/Q _2599_/A2 VDD VDD VSS VSS gf180mcu_fd_sc_mcu7t5v0__aoi211_1
XFILLER_46_109 VDD VDD VSS VSS gf180mcu_fd_sc_mcu7t5v0__fill_1
X_3219_ _3219_/A1 _3223_/A2 _3219_/B _4004_/D VDD VDD VSS VSS gf180mcu_fd_sc_mcu7t5v0__aoi21_1
X_4199_ _4199_/I _4199_/Z VDD VDD VSS VSS gf180mcu_fd_sc_mcu7t5v0__buf_1
XFILLER_54_120 VDD VDD VSS VSS gf180mcu_fd_sc_mcu7t5v0__fillcap_8
XFILLER_42_304 VDD VDD VSS VSS gf180mcu_fd_sc_mcu7t5v0__fill_2
XFILLER_108_166 VDD VDD VSS VSS gf180mcu_fd_sc_mcu7t5v0__fill_1
XFILLER_1_26 VDD VDD VSS VSS gf180mcu_fd_sc_mcu7t5v0__fill_1
XTAP_TAPCELL_ROW_5_282 VDD VSS gf180mcu_fd_sc_mcu7t5v0__filltie
XFILLER_77_267 VDD VDD VSS VSS gf180mcu_fd_sc_mcu7t5v0__fillcap_8
XFILLER_92_237 VDD VDD VSS VSS gf180mcu_fd_sc_mcu7t5v0__fill_2
XFILLER_45_142 VDD VDD VSS VSS gf180mcu_fd_sc_mcu7t5v0__fill_2
XFILLER_60_134 VDD VDD VSS VSS gf180mcu_fd_sc_mcu7t5v0__fill_2
XFILLER_81_72 VDD VDD VSS VSS gf180mcu_fd_sc_mcu7t5v0__fill_1
XFILLER_81_83 VDD VDD VSS VSS gf180mcu_fd_sc_mcu7t5v0__fill_2
X_3570_ _4142_/Q _3538_/B _3570_/A3 _3574_/A2 VDD VDD VSS VSS gf180mcu_fd_sc_mcu7t5v0__nand3_1
X_2521_ _2525_/A1 _2538_/B _2521_/B1 _2521_/B2 _3872_/D VDD VDD VSS VSS gf180mcu_fd_sc_mcu7t5v0__aoi22_1
XFILLER_114_136 VDD VDD VSS VSS gf180mcu_fd_sc_mcu7t5v0__fillcap_4
X_2452_ _2525_/A1 _2525_/A2 _2529_/A3 VDD VDD VSS VSS gf180mcu_fd_sc_mcu7t5v0__nor2_1
XPHY_EDGE_ROW_18_Right_18 VDD VSS gf180mcu_fd_sc_mcu7t5v0__endcap
X_2383_ _2383_/I _2402_/B VDD VDD VSS VSS gf180mcu_fd_sc_mcu7t5v0__clkinv_1
X_4122_ _4122_/D _4149_/CLK _4122_/Q VDD VDD VSS VSS gf180mcu_fd_sc_mcu7t5v0__dffq_1
X_4053_ _4053_/D _4058_/CLK _4053_/Q VDD VDD VSS VSS gf180mcu_fd_sc_mcu7t5v0__dffq_1
Xinput3 ext_rst_n_in input3/Z VDD VDD VSS VSS gf180mcu_fd_sc_mcu7t5v0__dlyb_1
X_3004_ _4005_/Q _3014_/A2 _3156_/A1 _3981_/Q _3007_/A3 VDD VDD VSS VSS gf180mcu_fd_sc_mcu7t5v0__aoi22_1
XFILLER_83_237 VDD VDD VSS VSS gf180mcu_fd_sc_mcu7t5v0__fillcap_8
XPHY_EDGE_ROW_27_Right_27 VDD VSS gf180mcu_fd_sc_mcu7t5v0__endcap
XTAP_TAPCELL_ROW_106_889 VDD VSS gf180mcu_fd_sc_mcu7t5v0__filltie
X_3906_ _3906_/D _4155_/CLK _3906_/Q VDD VDD VSS VSS gf180mcu_fd_sc_mcu7t5v0__dffq_1
X_3837_ _3837_/D clkload5/I _3837_/Q VDD VDD VSS VSS gf180mcu_fd_sc_mcu7t5v0__dffq_1
X_3768_ _3768_/D _4052_/CLK _3768_/Q VDD VDD VSS VSS gf180mcu_fd_sc_mcu7t5v0__dffq_1
X_2719_ _2719_/I _2722_/A1 VDD VDD VSS VSS gf180mcu_fd_sc_mcu7t5v0__clkinv_1
X_3699_ _3700_/A1 _3748_/A2 _3699_/Z VDD VDD VSS VSS gf180mcu_fd_sc_mcu7t5v0__and2_1
XPHY_EDGE_ROW_36_Right_36 VDD VSS gf180mcu_fd_sc_mcu7t5v0__endcap
XFILLER_105_136 VDD VDD VSS VSS gf180mcu_fd_sc_mcu7t5v0__fillcap_4
XFILLER_59_212 VDD VDD VSS VSS gf180mcu_fd_sc_mcu7t5v0__fillcap_4
XFILLER_120_139 VDD VDD VSS VSS gf180mcu_fd_sc_mcu7t5v0__fillcap_4
XFILLER_113_180 VDD VDD VSS VSS gf180mcu_fd_sc_mcu7t5v0__fill_1
XFILLER_59_245 VDD VDD VSS VSS gf180mcu_fd_sc_mcu7t5v0__fill_2
XFILLER_19_109 VDD VDD VSS VSS gf180mcu_fd_sc_mcu7t5v0__fillcap_8
XFILLER_27_142 VDD VDD VSS VSS gf180mcu_fd_sc_mcu7t5v0__fillcap_8
XTAP_TAPCELL_ROW_2_263 VDD VSS gf180mcu_fd_sc_mcu7t5v0__filltie
XFILLER_27_186 VDD VDD VSS VSS gf180mcu_fd_sc_mcu7t5v0__fill_1
XPHY_EDGE_ROW_45_Right_45 VDD VSS gf180mcu_fd_sc_mcu7t5v0__endcap
XFILLER_35_76 VDD VDD VSS VSS gf180mcu_fd_sc_mcu7t5v0__fill_2
XPHY_EDGE_ROW_106_Left_228 VDD VSS gf180mcu_fd_sc_mcu7t5v0__endcap
XFILLER_42_156 VDD VDD VSS VSS gf180mcu_fd_sc_mcu7t5v0__fillcap_8
XPHY_EDGE_ROW_115_Left_237 VDD VSS gf180mcu_fd_sc_mcu7t5v0__endcap
XPHY_EDGE_ROW_54_Right_54 VDD VSS gf180mcu_fd_sc_mcu7t5v0__endcap
XFILLER_97_329 VDD VDD VSS VSS gf180mcu_fd_sc_mcu7t5v0__fillcap_4
XTAP_TAPCELL_ROW_76_711 VDD VSS gf180mcu_fd_sc_mcu7t5v0__filltie
XPHY_EDGE_ROW_63_Right_63 VDD VSS gf180mcu_fd_sc_mcu7t5v0__endcap
XFILLER_61_410 VDD VDD VSS VSS gf180mcu_fd_sc_mcu7t5v0__fillcap_8
XFILLER_92_71 VDD VDD VSS VSS gf180mcu_fd_sc_mcu7t5v0__fill_2
X_1952_ _3993_/Q _3196_/A1 VDD VDD VSS VSS gf180mcu_fd_sc_mcu7t5v0__clkinv_1
X_1883_ _4133_/Q _3705_/A1 VDD VDD VSS VSS gf180mcu_fd_sc_mcu7t5v0__clkinv_1
X_3622_ hold208/Z _3669_/A2 _3669_/B1 _3622_/B2 _3623_/A2 VDD VDD VSS VSS gf180mcu_fd_sc_mcu7t5v0__aoi22_1
XPHY_EDGE_ROW_72_Right_72 VDD VSS gf180mcu_fd_sc_mcu7t5v0__endcap
X_3553_ _4113_/Q _4112_/Q _3578_/A1 _3557_/A1 VDD VDD VSS VSS gf180mcu_fd_sc_mcu7t5v0__nand3_1
X_2504_ _2465_/B _2504_/A2 _2538_/B VDD VDD VSS VSS gf180mcu_fd_sc_mcu7t5v0__nand2_1
X_3484_ _4085_/Q _3498_/A2 _3549_/B _3484_/B2 _3485_/A2 VDD VDD VSS VSS gf180mcu_fd_sc_mcu7t5v0__aoi22_1
X_2435_ _3808_/Q _2430_/Z _2436_/A3 VDD VDD VSS VSS gf180mcu_fd_sc_mcu7t5v0__nand2_1
XTAP_TAPCELL_ROW_99_847 VDD VSS gf180mcu_fd_sc_mcu7t5v0__filltie
X_2366_ hold198/Z _2372_/S _2367_/B VDD VDD VSS VSS gf180mcu_fd_sc_mcu7t5v0__nand2_1
X_4105_ _4105_/D _4142_/CLK _4105_/Q VDD VDD VSS VSS gf180mcu_fd_sc_mcu7t5v0__dffq_1
X_2297_ _3808_/Q _2300_/S _2298_/B VDD VDD VSS VSS gf180mcu_fd_sc_mcu7t5v0__nand2_1
XPHY_EDGE_ROW_81_Right_81 VDD VSS gf180mcu_fd_sc_mcu7t5v0__endcap
XFILLER_56_259 VDD VDD VSS VSS gf180mcu_fd_sc_mcu7t5v0__fill_1
X_4036_ _4036_/D _4166_/CLK _4036_/Q VDD VDD VSS VSS gf180mcu_fd_sc_mcu7t5v0__dffq_1
XFILLER_112_37 VDD VDD VSS VSS gf180mcu_fd_sc_mcu7t5v0__fillcap_64
XFILLER_24_112 VDD VDD VSS VSS gf180mcu_fd_sc_mcu7t5v0__fill_2
XTAP_TAPCELL_ROW_82_747 VDD VSS gf180mcu_fd_sc_mcu7t5v0__filltie
XTAP_TAPCELL_ROW_90_791 VDD VSS gf180mcu_fd_sc_mcu7t5v0__filltie
XPHY_EDGE_ROW_90_Right_90 VDD VSS gf180mcu_fd_sc_mcu7t5v0__endcap
XFILLER_21_67 VDD VDD VSS VSS gf180mcu_fd_sc_mcu7t5v0__fill_2
XFILLER_106_423 VDD VDD VSS VSS gf180mcu_fd_sc_mcu7t5v0__fill_2
Xmax_cap32 _2498_/S _2489_/C VDD VDD VSS VSS gf180mcu_fd_sc_mcu7t5v0__buf_2
XFILLER_55_270 VDD VDD VSS VSS gf180mcu_fd_sc_mcu7t5v0__fillcap_8
Xmax_cap54 _3638_/A2 _3679_/A1 VDD VDD VSS VSS gf180mcu_fd_sc_mcu7t5v0__buf_2
Xmax_cap43 _3223_/A2 _3217_/A2 VDD VDD VSS VSS gf180mcu_fd_sc_mcu7t5v0__buf_2
Xmax_cap87 _3853_/Q _3288_/A1 VDD VDD VSS VSS gf180mcu_fd_sc_mcu7t5v0__buf_4
Xmax_cap76 wire77/Z _2404_/B VDD VDD VSS VSS gf180mcu_fd_sc_mcu7t5v0__clkbuf_2
Xmax_cap65 _3241_/A1 _3036_/A2 VDD VDD VSS VSS gf180mcu_fd_sc_mcu7t5v0__buf_2
XFILLER_15_167 VDD VDD VSS VSS gf180mcu_fd_sc_mcu7t5v0__fill_2
XFILLER_30_148 VDD VDD VSS VSS gf180mcu_fd_sc_mcu7t5v0__fillcap_8
XFILLER_7_58 VDD VDD VSS VSS gf180mcu_fd_sc_mcu7t5v0__fill_2
XFILLER_30_6 VDD VDD VSS VSS gf180mcu_fd_sc_mcu7t5v0__fill_1
X_2220_ _3794_/Q _2111_/Z _3746_/B _2221_/A2 VDD VDD VSS VSS gf180mcu_fd_sc_mcu7t5v0__oai21_1
XTAP_TAPCELL_ROW_96_828 VDD VSS gf180mcu_fd_sc_mcu7t5v0__filltie
X_2151_ _2151_/A1 _2151_/A2 _3770_/D VDD VDD VSS VSS gf180mcu_fd_sc_mcu7t5v0__nor2_1
XFILLER_78_384 VDD VDD VSS VSS gf180mcu_fd_sc_mcu7t5v0__fill_1
XFILLER_78_395 VDD VDD VSS VSS gf180mcu_fd_sc_mcu7t5v0__fill_2
X_2082_ _3085_/A1 _3070_/A1 _2082_/B hold127/I VDD VDD VSS VSS gf180mcu_fd_sc_mcu7t5v0__oai21_1
XTAP_TAPCELL_ROW_116_951 VDD VSS gf180mcu_fd_sc_mcu7t5v0__filltie
XFILLER_53_207 VDD VDD VSS VSS gf180mcu_fd_sc_mcu7t5v0__fill_2
XFILLER_21_104 VDD VDD VSS VSS gf180mcu_fd_sc_mcu7t5v0__fillcap_16
XFILLER_61_295 VDD VDD VSS VSS gf180mcu_fd_sc_mcu7t5v0__fill_1
X_2984_ _2984_/A1 _2984_/A2 _2984_/A3 _2985_/C VDD VDD VSS VSS gf180mcu_fd_sc_mcu7t5v0__nand3_1
X_1935_ _1935_/I _3232_/A1 VDD VDD VSS VSS gf180mcu_fd_sc_mcu7t5v0__clkinv_1
X_3605_ _3731_/C _3605_/A2 _4114_/D VDD VDD VSS VSS gf180mcu_fd_sc_mcu7t5v0__nor2_1
X_3536_ _3536_/A1 _3536_/A2 _3536_/B _3536_/C _3536_/ZN VDD VDD VSS VSS gf180mcu_fd_sc_mcu7t5v0__aoi211_1
XFILLER_103_415 VDD VDD VSS VSS gf180mcu_fd_sc_mcu7t5v0__fillcap_4
X_3467_ _4081_/Q _4080_/Q _3467_/Z VDD VDD VSS VSS gf180mcu_fd_sc_mcu7t5v0__xor2_1
XFILLER_88_126 VDD VDD VSS VSS gf180mcu_fd_sc_mcu7t5v0__fillcap_4
X_2418_ _3853_/Q wire51/Z wire77/Z _3813_/Q _2419_/I VDD VDD VSS VSS gf180mcu_fd_sc_mcu7t5v0__aoi22_1
X_3398_ _4105_/Q _4064_/Q _3398_/A3 _3398_/Z VDD VDD VSS VSS gf180mcu_fd_sc_mcu7t5v0__and3_1
X_2349_ _3834_/Q _2273_/Z _2349_/B _2356_/B _2350_/B VDD VDD VSS VSS gf180mcu_fd_sc_mcu7t5v0__aoi211_1
XTAP_TAPCELL_ROW_27_416 VDD VSS gf180mcu_fd_sc_mcu7t5v0__filltie
X_4019_ _4019_/D clkload2/I _4019_/Q VDD VDD VSS VSS gf180mcu_fd_sc_mcu7t5v0__dffq_1
XFILLER_83_18 VDD VDD VSS VSS gf180mcu_fd_sc_mcu7t5v0__fill_2
XFILLER_84_387 VDD VDD VSS VSS gf180mcu_fd_sc_mcu7t5v0__fill_2
XPHY_EDGE_ROW_0_Right_0 VDD VSS gf180mcu_fd_sc_mcu7t5v0__endcap
XFILLER_12_104 VDD VDD VSS VSS gf180mcu_fd_sc_mcu7t5v0__fill_1
XTAP_TAPCELL_ROW_35_460 VDD VSS gf180mcu_fd_sc_mcu7t5v0__filltie
XFILLER_40_424 VDD VDD VSS VSS gf180mcu_fd_sc_mcu7t5v0__fill_2
XFILLER_20_181 VDD VDD VSS VSS gf180mcu_fd_sc_mcu7t5v0__fillcap_32
XFILLER_32_77 VDD VDD VSS VSS gf180mcu_fd_sc_mcu7t5v0__fillcap_4
XFILLER_4_314 VDD VDD VSS VSS gf180mcu_fd_sc_mcu7t5v0__fill_1
XFILLER_121_212 VDD VDD VSS VSS gf180mcu_fd_sc_mcu7t5v0__fill_1
XFILLER_79_137 VDD VDD VSS VSS gf180mcu_fd_sc_mcu7t5v0__fill_2
XFILLER_75_343 VDD VDD VSS VSS gf180mcu_fd_sc_mcu7t5v0__fill_1
XTAP_TAPCELL_ROW_93_809 VDD VSS gf180mcu_fd_sc_mcu7t5v0__filltie
XFILLER_90_313 VDD VDD VSS VSS gf180mcu_fd_sc_mcu7t5v0__fill_2
XFILLER_90_302 VDD VDD VSS VSS gf180mcu_fd_sc_mcu7t5v0__fill_1
XPHY_EDGE_ROW_121_Right_121 VDD VSS gf180mcu_fd_sc_mcu7t5v0__endcap
XTAP_TAPCELL_ROW_113_932 VDD VSS gf180mcu_fd_sc_mcu7t5v0__filltie
XFILLER_31_413 VDD VDD VSS VSS gf180mcu_fd_sc_mcu7t5v0__fillcap_4
XFILLER_43_273 VDD VDD VSS VSS gf180mcu_fd_sc_mcu7t5v0__fillcap_4
XFILLER_73_84 VDD VDD VSS VSS gf180mcu_fd_sc_mcu7t5v0__fill_1
XTAP_TAPCELL_ROW_41_496 VDD VSS gf180mcu_fd_sc_mcu7t5v0__filltie
Xhold119 _4162_/Q _4163_/D VDD VDD VSS VSS gf180mcu_fd_sc_mcu7t5v0__dlyc_1
X_3321_ _4047_/Q _4046_/Q _4045_/Q _3310_/Z _3321_/Z VDD VDD VSS VSS gf180mcu_fd_sc_mcu7t5v0__and4_1
X_3252_ _3852_/Q _3257_/A2 _3256_/B _3253_/B VDD VDD VSS VSS gf180mcu_fd_sc_mcu7t5v0__oai21_1
X_3183_ _3183_/A1 wire44/Z _3183_/B _3987_/D VDD VDD VSS VSS gf180mcu_fd_sc_mcu7t5v0__aoi21_1
X_2203_ _4086_/Q _2248_/A2 _2205_/A1 VDD VDD VSS VSS gf180mcu_fd_sc_mcu7t5v0__nor2_1
X_2134_ hold224/Z _2155_/A2 _2136_/A1 VDD VDD VSS VSS gf180mcu_fd_sc_mcu7t5v0__nor2_1
XFILLER_93_151 VDD VDD VSS VSS gf180mcu_fd_sc_mcu7t5v0__fillcap_4
X_2065_ _3893_/Q _2756_/A2 VDD VDD VSS VSS gf180mcu_fd_sc_mcu7t5v0__clkinv_1
XFILLER_19_292 VDD VDD VSS VSS gf180mcu_fd_sc_mcu7t5v0__fillcap_16
X_2967_ hold153/Z _2999_/A2 _2999_/B1 _2967_/B2 _2968_/A2 VDD VDD VSS VSS gf180mcu_fd_sc_mcu7t5v0__aoi22_1
X_1918_ _4027_/Q _3268_/A1 VDD VDD VSS VSS gf180mcu_fd_sc_mcu7t5v0__clkinv_1
X_2898_ _3971_/Q _3913_/Q _2903_/B VDD VDD VSS VSS gf180mcu_fd_sc_mcu7t5v0__nand2_1
XFILLER_78_18 VDD VDD VSS VSS gf180mcu_fd_sc_mcu7t5v0__fillcap_4
X_3519_ _3519_/A1 _3519_/A2 _4093_/D VDD VDD VSS VSS gf180mcu_fd_sc_mcu7t5v0__nor2_1
XFILLER_1_339 VDD VDD VSS VSS gf180mcu_fd_sc_mcu7t5v0__fillcap_8
XFILLER_103_212 VDD VDD VSS VSS gf180mcu_fd_sc_mcu7t5v0__fillcap_4
XFILLER_76_107 VDD VDD VSS VSS gf180mcu_fd_sc_mcu7t5v0__fillcap_4
Xclkbuf_1_1__f_signal_input_regs clkbuf_0_signal_input_regs/Z _4079_/CLK VDD VDD VSS
+ VSS gf180mcu_fd_sc_mcu7t5v0__clkbuf_16
XFILLER_103_278 VDD VDD VSS VSS gf180mcu_fd_sc_mcu7t5v0__fill_2
XFILLER_57_332 VDD VDD VSS VSS gf180mcu_fd_sc_mcu7t5v0__fill_1
XFILLER_84_162 VDD VDD VSS VSS gf180mcu_fd_sc_mcu7t5v0__fillcap_8
XTAP_TAPCELL_ROW_110_913 VDD VSS gf180mcu_fd_sc_mcu7t5v0__filltie
XFILLER_40_243 VDD VDD VSS VSS gf180mcu_fd_sc_mcu7t5v0__fill_2
XFILLER_43_43 VDD VDD VSS VSS gf180mcu_fd_sc_mcu7t5v0__fillcap_16
XFILLER_4_37 VDD VDD VSS VSS gf180mcu_fd_sc_mcu7t5v0__fill_1
XFILLER_4_177 VDD VDD VSS VSS gf180mcu_fd_sc_mcu7t5v0__fillcap_8
XFILLER_75_162 VDD VDD VSS VSS gf180mcu_fd_sc_mcu7t5v0__fillcap_4
XFILLER_90_132 VDD VDD VSS VSS gf180mcu_fd_sc_mcu7t5v0__fillcap_8
XFILLER_16_273 VDD VDD VSS VSS gf180mcu_fd_sc_mcu7t5v0__fillcap_32
X_3870_ _3870_/D _4021_/CLK _3870_/Q VDD VDD VSS VSS gf180mcu_fd_sc_mcu7t5v0__dffq_1
X_2821_ _2815_/B _2814_/Z _2821_/B _2836_/B1 VDD VDD VSS VSS gf180mcu_fd_sc_mcu7t5v0__oai21_1
X_2752_ _2750_/Z _2751_/Z _2756_/B VDD VDD VSS VSS gf180mcu_fd_sc_mcu7t5v0__nand2_1
XFILLER_31_298 VDD VDD VSS VSS gf180mcu_fd_sc_mcu7t5v0__fillcap_8
XFILLER_117_315 VDD VDD VSS VSS gf180mcu_fd_sc_mcu7t5v0__fill_1
X_2683_ _3283_/A1 _3912_/Q _3911_/Q _2683_/C _2684_/C VDD VDD VSS VSS gf180mcu_fd_sc_mcu7t5v0__oai211_1
X_3304_ _4042_/Q _3302_/Z _3306_/A2 VDD VDD VSS VSS gf180mcu_fd_sc_mcu7t5v0__nor2_1
XFILLER_98_243 VDD VDD VSS VSS gf180mcu_fd_sc_mcu7t5v0__fill_2
X_3235_ _3286_/A1 _3240_/A2 wire81/I _3236_/B VDD VDD VSS VSS gf180mcu_fd_sc_mcu7t5v0__oai21_1
XFILLER_58_107 VDD VDD VSS VSS gf180mcu_fd_sc_mcu7t5v0__fillcap_8
XTAP_TAPCELL_ROW_69_669 VDD VSS gf180mcu_fd_sc_mcu7t5v0__filltie
X_3166_ _3166_/A1 _3170_/A2 _3166_/B _3979_/D VDD VDD VSS VSS gf180mcu_fd_sc_mcu7t5v0__aoi21_1
X_3097_ wire90/I _3104_/A2 wire81/I _3098_/B VDD VDD VSS VSS gf180mcu_fd_sc_mcu7t5v0__oai21_1
X_2117_ hold218/Z _2243_/A2 _3746_/B _2118_/A2 VDD VDD VSS VSS gf180mcu_fd_sc_mcu7t5v0__oai21_1
X_2048_ _3912_/Q _2887_/A2 VDD VDD VSS VSS gf180mcu_fd_sc_mcu7t5v0__clkinv_1
XFILLER_120_37 VDD VDD VSS VSS gf180mcu_fd_sc_mcu7t5v0__fillcap_4
X_3999_ _3999_/D _4170_/CLK _3999_/Q VDD VDD VSS VSS gf180mcu_fd_sc_mcu7t5v0__dffq_1
XFILLER_89_276 VDD VDD VSS VSS gf180mcu_fd_sc_mcu7t5v0__fillcap_4
XFILLER_38_54 VDD VDD VSS VSS gf180mcu_fd_sc_mcu7t5v0__fill_1
XFILLER_57_151 VDD VDD VSS VSS gf180mcu_fd_sc_mcu7t5v0__fillcap_4
XFILLER_9_214 VDD VDD VSS VSS gf180mcu_fd_sc_mcu7t5v0__fill_1
Xclkload17 _4164_/CLK clkload17/ZN VDD VDD VSS VSS gf180mcu_fd_sc_mcu7t5v0__clkinv_8
Xclkload28 _3550_/A2 clkload28/Z VDD VDD VSS VSS gf180mcu_fd_sc_mcu7t5v0__clkbuf_2
XFILLER_55_8 VDD VDD VSS VSS gf180mcu_fd_sc_mcu7t5v0__fill_1
XFILLER_79_72 VDD VDD VSS VSS gf180mcu_fd_sc_mcu7t5v0__fillcap_16
XFILLER_107_370 VDD VDD VSS VSS gf180mcu_fd_sc_mcu7t5v0__fill_1
XFILLER_48_140 VDD VDD VSS VSS gf180mcu_fd_sc_mcu7t5v0__fillcap_16
X_3020_ _3022_/A3 _2947_/Z _3083_/A1 VDD VDD VSS VSS gf180mcu_fd_sc_mcu7t5v0__nor2_1
XFILLER_63_110 VDD VDD VSS VSS gf180mcu_fd_sc_mcu7t5v0__fillcap_4
XFILLER_63_154 VDD VDD VSS VSS gf180mcu_fd_sc_mcu7t5v0__fill_1
XTAP_TAPCELL_ROW_74_694 VDD VSS gf180mcu_fd_sc_mcu7t5v0__filltie
X_3922_ _3922_/D _4166_/CLK _3922_/Q VDD VDD VSS VSS gf180mcu_fd_sc_mcu7t5v0__dffq_1
X_3853_ _3853_/D clkload7/I _3853_/Q VDD VDD VSS VSS gf180mcu_fd_sc_mcu7t5v0__dffq_1
X_2804_ _3958_/Q _3900_/Q _2804_/B _2806_/A3 VDD VDD VSS VSS gf180mcu_fd_sc_mcu7t5v0__aoi21_1
X_3784_ _3784_/D _4104_/CLK _3784_/Q VDD VDD VSS VSS gf180mcu_fd_sc_mcu7t5v0__dffq_1
X_2735_ _2735_/A1 _2735_/A2 _2736_/B VDD VDD VSS VSS gf180mcu_fd_sc_mcu7t5v0__or2_1
X_2666_ _3262_/A1 _3902_/Q _2686_/A3 VDD VDD VSS VSS gf180mcu_fd_sc_mcu7t5v0__nor2_1
X_2597_ _2597_/A1 _2597_/A2 _2597_/B _2603_/A1 VDD VDD VSS VSS gf180mcu_fd_sc_mcu7t5v0__oai21_1
XFILLER_115_59 VDD VDD VSS VSS gf180mcu_fd_sc_mcu7t5v0__fill_2
X_4198_ _4198_/I _4198_/Z VDD VDD VSS VSS gf180mcu_fd_sc_mcu7t5v0__buf_1
X_3218_ _3286_/A1 _3223_/A2 wire81/Z _3219_/B VDD VDD VSS VSS gf180mcu_fd_sc_mcu7t5v0__oai21_1
XPHY_EDGE_ROW_19_Left_141 VDD VSS gf180mcu_fd_sc_mcu7t5v0__endcap
X_3149_ _3149_/A1 _3151_/A2 _3149_/B _3971_/D VDD VDD VSS VSS gf180mcu_fd_sc_mcu7t5v0__aoi21_1
XFILLER_91_18 VDD VDD VSS VSS gf180mcu_fd_sc_mcu7t5v0__fill_2
XFILLER_24_45 VDD VDD VSS VSS gf180mcu_fd_sc_mcu7t5v0__fill_2
XPHY_EDGE_ROW_28_Left_150 VDD VSS gf180mcu_fd_sc_mcu7t5v0__endcap
XFILLER_40_66 VDD VDD VSS VSS gf180mcu_fd_sc_mcu7t5v0__fill_2
XFILLER_2_423 VDD VDD VSS VSS gf180mcu_fd_sc_mcu7t5v0__fill_2
XFILLER_108_189 VDD VDD VSS VSS gf180mcu_fd_sc_mcu7t5v0__fill_1
XFILLER_77_279 VDD VDD VSS VSS gf180mcu_fd_sc_mcu7t5v0__fill_1
XTAP_TAPCELL_ROW_5_283 VDD VSS gf180mcu_fd_sc_mcu7t5v0__filltie
XFILLER_45_110 VDD VDD VSS VSS gf180mcu_fd_sc_mcu7t5v0__fillcap_4
XFILLER_45_165 VDD VDD VSS VSS gf180mcu_fd_sc_mcu7t5v0__fillcap_16
Xclkbuf_1_1__f__1477_ clkbuf_0__1477_/Z _3549_/B VDD VDD VSS VSS gf180mcu_fd_sc_mcu7t5v0__clkbuf_16
X_2520_ _3808_/Q _2506_/Z _2520_/B _2521_/B2 VDD VDD VSS VSS gf180mcu_fd_sc_mcu7t5v0__aoi21_1
XFILLER_114_115 VDD VDD VSS VSS gf180mcu_fd_sc_mcu7t5v0__fill_1
XFILLER_114_104 VDD VDD VSS VSS gf180mcu_fd_sc_mcu7t5v0__fill_1
X_2451_ _2548_/A1 _2451_/A2 _2451_/B _3256_/B _3862_/D VDD VDD VSS VSS gf180mcu_fd_sc_mcu7t5v0__oai211_1
XFILLER_46_4 VDD VDD VSS VSS gf180mcu_fd_sc_mcu7t5v0__fill_1
X_2382_ _3882_/Q _4157_/Q _2380_/Z _2557_/A2 VDD VDD VSS VSS gf180mcu_fd_sc_mcu7t5v0__nor3_1
X_4121_ _4121_/D _4149_/CLK _4121_/Q VDD VDD VSS VSS gf180mcu_fd_sc_mcu7t5v0__dffq_1
X_4052_ _4052_/D _4052_/CLK _4052_/Q VDD VDD VSS VSS gf180mcu_fd_sc_mcu7t5v0__dffq_1
XFILLER_110_376 VDD VDD VSS VSS gf180mcu_fd_sc_mcu7t5v0__fillcap_8
Xinput4 i2c_scl_in input4/Z VDD VDD VSS VSS gf180mcu_fd_sc_mcu7t5v0__dlyb_1
X_3003_ _3989_/Q _3173_/A1 _3013_/B1 _3997_/Q _3007_/A2 VDD VDD VSS VSS gf180mcu_fd_sc_mcu7t5v0__aoi22_1
X_3905_ _3905_/D _4034_/CLK _3905_/Q VDD VDD VSS VSS gf180mcu_fd_sc_mcu7t5v0__dffq_1
X_3836_ _3836_/D clkload8/I _3836_/Q VDD VDD VSS VSS gf180mcu_fd_sc_mcu7t5v0__dffq_1
X_3767_ _3767_/D _4052_/CLK _3767_/Q VDD VDD VSS VSS gf180mcu_fd_sc_mcu7t5v0__dffq_1
X_2718_ _3947_/Q _3889_/Q _2719_/I VDD VDD VSS VSS gf180mcu_fd_sc_mcu7t5v0__xor2_1
X_3698_ _3698_/A1 _3678_/Z _3698_/B _3746_/B _4131_/D VDD VDD VSS VSS gf180mcu_fd_sc_mcu7t5v0__oai211_1
X_2649_ _4038_/Q _2915_/A2 _2651_/A2 _4037_/Q _2651_/B VDD VDD VSS VSS gf180mcu_fd_sc_mcu7t5v0__oai22_1
XFILLER_120_107 VDD VDD VSS VSS gf180mcu_fd_sc_mcu7t5v0__fill_2
XFILLER_86_18 VDD VDD VSS VSS gf180mcu_fd_sc_mcu7t5v0__fillcap_16
XFILLER_99_393 VDD VDD VSS VSS gf180mcu_fd_sc_mcu7t5v0__fill_2
XFILLER_101_310 VDD VDD VSS VSS gf180mcu_fd_sc_mcu7t5v0__fillcap_16
XFILLER_19_56 VDD VDD VSS VSS gf180mcu_fd_sc_mcu7t5v0__fillcap_4
XTAP_TAPCELL_ROW_2_264 VDD VSS gf180mcu_fd_sc_mcu7t5v0__filltie
XFILLER_42_102 VDD VDD VSS VSS gf180mcu_fd_sc_mcu7t5v0__fill_2
XFILLER_15_349 VDD VDD VSS VSS gf180mcu_fd_sc_mcu7t5v0__fill_1
XFILLER_35_55 VDD VDD VSS VSS gf180mcu_fd_sc_mcu7t5v0__fill_1
XFILLER_30_319 VDD VDD VSS VSS gf180mcu_fd_sc_mcu7t5v0__fill_1
XFILLER_51_65 VDD VDD VSS VSS gf180mcu_fd_sc_mcu7t5v0__fillcap_4
XFILLER_2_297 VDD VDD VSS VSS gf180mcu_fd_sc_mcu7t5v0__fillcap_16
XFILLER_38_419 VDD VDD VSS VSS gf180mcu_fd_sc_mcu7t5v0__fillcap_4
XFILLER_76_62 VDD VDD VSS VSS gf180mcu_fd_sc_mcu7t5v0__fillcap_8
XFILLER_61_422 VDD VDD VSS VSS gf180mcu_fd_sc_mcu7t5v0__fillcap_4
XFILLER_92_50 VDD VDD VSS VSS gf180mcu_fd_sc_mcu7t5v0__fillcap_8
Xclkbuf_1_1__f__1529_ clkbuf_0__1529_/Z _3536_/B VDD VDD VSS VSS gf180mcu_fd_sc_mcu7t5v0__clkbuf_16
X_1951_ _1951_/I _3198_/A1 VDD VDD VSS VSS gf180mcu_fd_sc_mcu7t5v0__clkinv_1
XFILLER_119_218 VDD VDD VSS VSS gf180mcu_fd_sc_mcu7t5v0__fillcap_8
X_1882_ _4134_/Q _3707_/A1 VDD VDD VSS VSS gf180mcu_fd_sc_mcu7t5v0__clkinv_1
X_3621_ _3621_/A1 _3621_/A2 _3622_/B2 VDD VDD VSS VSS gf180mcu_fd_sc_mcu7t5v0__nand2_1
X_3552_ _3552_/A1 _3552_/A2 _3552_/B _3552_/C _4105_/D VDD VDD VSS VSS gf180mcu_fd_sc_mcu7t5v0__aoi211_1
X_2503_ _2465_/B _2504_/A2 _2510_/B VDD VDD VSS VSS gf180mcu_fd_sc_mcu7t5v0__and2_1
X_3483_ _3481_/Z _3483_/A2 _3484_/B2 VDD VDD VSS VSS gf180mcu_fd_sc_mcu7t5v0__nor2_1
X_2434_ _3856_/Q _2451_/A2 _2436_/A2 VDD VDD VSS VSS gf180mcu_fd_sc_mcu7t5v0__nand2_1
XFILLER_102_107 VDD VDD VSS VSS gf180mcu_fd_sc_mcu7t5v0__fillcap_4
X_2365_ _2377_/A1 _2372_/S _2365_/B _3825_/D VDD VDD VSS VSS gf180mcu_fd_sc_mcu7t5v0__oai21_1
XTAP_TAPCELL_ROW_99_848 VDD VSS gf180mcu_fd_sc_mcu7t5v0__filltie
XFILLER_29_408 VDD VDD VSS VSS gf180mcu_fd_sc_mcu7t5v0__fillcap_8
X_4104_ _4104_/D _4104_/CLK _4104_/Q VDD VDD VSS VSS gf180mcu_fd_sc_mcu7t5v0__dffq_1
X_2296_ _2377_/A1 _2296_/A2 _2296_/B _3807_/D VDD VDD VSS VSS gf180mcu_fd_sc_mcu7t5v0__oai21_1
X_4035_ _4035_/D _4169_/CLK _4035_/Q VDD VDD VSS VSS gf180mcu_fd_sc_mcu7t5v0__dffq_1
XFILLER_24_124 VDD VDD VSS VSS gf180mcu_fd_sc_mcu7t5v0__fillcap_16
XFILLER_52_422 VDD VDD VSS VSS gf180mcu_fd_sc_mcu7t5v0__fillcap_4
XTAP_TAPCELL_ROW_90_792 VDD VSS gf180mcu_fd_sc_mcu7t5v0__filltie
X_3819_ _3819_/D clkload8/I _3819_/Q VDD VDD VSS VSS gf180mcu_fd_sc_mcu7t5v0__dffq_1
XFILLER_118_251 VDD VDD VSS VSS gf180mcu_fd_sc_mcu7t5v0__fill_2
XFILLER_97_17 VDD VDD VSS VSS gf180mcu_fd_sc_mcu7t5v0__fill_1
XPHY_EDGE_ROW_102_Right_102 VDD VSS gf180mcu_fd_sc_mcu7t5v0__endcap
Xmax_cap33 _2482_/S _2498_/S VDD VDD VSS VSS gf180mcu_fd_sc_mcu7t5v0__buf_2
Xmax_cap55 _3667_/A2 _3700_/A1 VDD VDD VSS VSS gf180mcu_fd_sc_mcu7t5v0__buf_2
XTAP_TAPCELL_ROW_38_480 VDD VSS gf180mcu_fd_sc_mcu7t5v0__filltie
Xmax_cap88 _3286_/A1 _3754_/I1 VDD VDD VSS VSS gf180mcu_fd_sc_mcu7t5v0__buf_4
XFILLER_55_282 VDD VDD VSS VSS gf180mcu_fd_sc_mcu7t5v0__fill_2
Xmax_cap66 _3027_/C1 _3275_/A1 VDD VDD VSS VSS gf180mcu_fd_sc_mcu7t5v0__buf_2
XFILLER_70_230 VDD VDD VSS VSS gf180mcu_fd_sc_mcu7t5v0__fill_1
XFILLER_15_179 VDD VDD VSS VSS gf180mcu_fd_sc_mcu7t5v0__fillcap_16
XFILLER_30_127 VDD VDD VSS VSS gf180mcu_fd_sc_mcu7t5v0__fillcap_8
XFILLER_62_31 VDD VDD VSS VSS gf180mcu_fd_sc_mcu7t5v0__fillcap_4
XFILLER_70_296 VDD VDD VSS VSS gf180mcu_fd_sc_mcu7t5v0__fill_2
XFILLER_62_75 VDD VDD VSS VSS gf180mcu_fd_sc_mcu7t5v0__fill_2
XFILLER_11_352 VDD VDD VSS VSS gf180mcu_fd_sc_mcu7t5v0__fillcap_64
XTAP_TAPCELL_ROW_21_380 VDD VSS gf180mcu_fd_sc_mcu7t5v0__filltie
XFILLER_112_416 VDD VDD VSS VSS gf180mcu_fd_sc_mcu7t5v0__fillcap_8
XFILLER_23_6 VDD VDD VSS VSS gf180mcu_fd_sc_mcu7t5v0__fill_1
XFILLER_87_72 VDD VDD VSS VSS gf180mcu_fd_sc_mcu7t5v0__fillcap_16
XTAP_TAPCELL_ROW_96_829 VDD VSS gf180mcu_fd_sc_mcu7t5v0__filltie
X_2150_ _3770_/Q _2243_/A2 _3746_/B _2151_/A2 VDD VDD VSS VSS gf180mcu_fd_sc_mcu7t5v0__oai21_1
X_2081_ _3070_/A1 hold126/Z _2082_/B VDD VDD VSS VSS gf180mcu_fd_sc_mcu7t5v0__nand2_1
X_2983_ _3947_/Q _3088_/A1 _3057_/A1 _3933_/Q _2984_/A3 VDD VDD VSS VSS gf180mcu_fd_sc_mcu7t5v0__aoi22_1
XFILLER_21_138 VDD VDD VSS VSS gf180mcu_fd_sc_mcu7t5v0__fill_2
X_1934_ _4011_/Q _3234_/A1 VDD VDD VSS VSS gf180mcu_fd_sc_mcu7t5v0__clkinv_1
X_3604_ hold160/Z _3669_/A2 _3669_/B1 _3604_/B2 _3605_/A2 VDD VDD VSS VSS gf180mcu_fd_sc_mcu7t5v0__aoi22_1
X_3535_ _3552_/C _3535_/A2 _3535_/A3 _4097_/D VDD VDD VSS VSS gf180mcu_fd_sc_mcu7t5v0__nor3_1
XFILLER_115_243 VDD VDD VSS VSS gf180mcu_fd_sc_mcu7t5v0__fill_2
X_3466_ _4081_/Q _4080_/Q _3471_/A2 VDD VDD VSS VSS gf180mcu_fd_sc_mcu7t5v0__nand2_1
X_2417_ _2417_/I _3852_/D VDD VDD VSS VSS gf180mcu_fd_sc_mcu7t5v0__clkinv_1
XFILLER_69_341 VDD VDD VSS VSS gf180mcu_fd_sc_mcu7t5v0__fill_1
X_3397_ _4105_/Q _3398_/A3 _3400_/A2 VDD VDD VSS VSS gf180mcu_fd_sc_mcu7t5v0__nand2_1
X_2348_ _2343_/S _2348_/A2 _2348_/B _2362_/C _3820_/D VDD VDD VSS VSS gf180mcu_fd_sc_mcu7t5v0__aoi211_1
X_2279_ _3861_/Q _3831_/Q _2279_/Z VDD VDD VSS VSS gf180mcu_fd_sc_mcu7t5v0__xor2_1
XTAP_TAPCELL_ROW_27_417 VDD VSS gf180mcu_fd_sc_mcu7t5v0__filltie
X_4018_ _4018_/D _4021_/CLK _4018_/Q VDD VDD VSS VSS gf180mcu_fd_sc_mcu7t5v0__dffq_1
XFILLER_25_422 VDD VDD VSS VSS gf180mcu_fd_sc_mcu7t5v0__fillcap_4
XFILLER_52_241 VDD VDD VSS VSS gf180mcu_fd_sc_mcu7t5v0__fillcap_4
XTAP_TAPCELL_ROW_35_461 VDD VSS gf180mcu_fd_sc_mcu7t5v0__filltie
XFILLER_79_105 VDD VDD VSS VSS gf180mcu_fd_sc_mcu7t5v0__fillcap_32
XFILLER_106_276 VDD VDD VSS VSS gf180mcu_fd_sc_mcu7t5v0__fillcap_16
XFILLER_57_31 VDD VDD VSS VSS gf180mcu_fd_sc_mcu7t5v0__fill_1
XFILLER_28_260 VDD VDD VSS VSS gf180mcu_fd_sc_mcu7t5v0__fill_2
XTAP_TAPCELL_ROW_113_933 VDD VSS gf180mcu_fd_sc_mcu7t5v0__filltie
XFILLER_73_52 VDD VDD VSS VSS gf180mcu_fd_sc_mcu7t5v0__fill_1
XFILLER_7_120 VDD VDD VSS VSS gf180mcu_fd_sc_mcu7t5v0__fillcap_4
XTAP_TAPCELL_ROW_41_497 VDD VSS gf180mcu_fd_sc_mcu7t5v0__filltie
XFILLER_11_193 VDD VDD VSS VSS gf180mcu_fd_sc_mcu7t5v0__fill_2
XFILLER_7_142 VDD VDD VSS VSS gf180mcu_fd_sc_mcu7t5v0__fillcap_4
XFILLER_7_175 VDD VDD VSS VSS gf180mcu_fd_sc_mcu7t5v0__fillcap_4
X_3320_ _4047_/Q _3318_/Z _3322_/A2 VDD VDD VSS VSS gf180mcu_fd_sc_mcu7t5v0__nor2_1
XFILLER_98_82 VDD VDD VSS VSS gf180mcu_fd_sc_mcu7t5v0__fillcap_4
XFILLER_98_425 VDD VDD VSS VSS gf180mcu_fd_sc_mcu7t5v0__fill_1
X_3251_ _3251_/A1 _3257_/A2 _3251_/B _4019_/D VDD VDD VSS VSS gf180mcu_fd_sc_mcu7t5v0__aoi21_1
X_3182_ wire90/I wire44/Z wire81/I _3183_/B VDD VDD VSS VSS gf180mcu_fd_sc_mcu7t5v0__oai21_1
X_2202_ _2202_/A1 _2202_/A2 _3787_/D VDD VDD VSS VSS gf180mcu_fd_sc_mcu7t5v0__nor2_1
XFILLER_14_2 VDD VDD VSS VSS gf180mcu_fd_sc_mcu7t5v0__fillcap_8
XFILLER_93_130 VDD VDD VSS VSS gf180mcu_fd_sc_mcu7t5v0__fill_2
X_2133_ _2133_/A1 _2133_/A2 _3764_/D VDD VDD VSS VSS gf180mcu_fd_sc_mcu7t5v0__nor2_1
X_2064_ _3894_/Q _2763_/A2 VDD VDD VSS VSS gf180mcu_fd_sc_mcu7t5v0__clkinv_1
XFILLER_34_230 VDD VDD VSS VSS gf180mcu_fd_sc_mcu7t5v0__fill_2
XFILLER_22_425 VDD VDD VSS VSS gf180mcu_fd_sc_mcu7t5v0__fill_1
XTAP_TAPCELL_ROW_32_442 VDD VSS gf180mcu_fd_sc_mcu7t5v0__filltie
X_2966_ _2966_/A1 _2966_/A2 _2966_/A3 _2966_/A4 _2967_/B2 VDD VDD VSS VSS gf180mcu_fd_sc_mcu7t5v0__nand4_1
X_2897_ _2897_/A1 _2897_/A2 _2897_/B1 _2897_/B2 _2897_/C _2908_/A1 VDD VDD VSS VSS
+ gf180mcu_fd_sc_mcu7t5v0__aoi221_1
X_1917_ _4028_/Q _3270_/A1 VDD VDD VSS VSS gf180mcu_fd_sc_mcu7t5v0__clkinv_1
XFILLER_1_307 VDD VDD VSS VSS gf180mcu_fd_sc_mcu7t5v0__fillcap_32
XFILLER_89_414 VDD VDD VSS VSS gf180mcu_fd_sc_mcu7t5v0__fillcap_4
X_3518_ _4093_/Q _3511_/Z _3538_/B _3519_/A2 VDD VDD VSS VSS gf180mcu_fd_sc_mcu7t5v0__oai21_1
XFILLER_103_224 VDD VDD VSS VSS gf180mcu_fd_sc_mcu7t5v0__fillcap_8
X_3449_ _4095_/Q _4094_/Q _4093_/Q _3450_/A2 VDD VDD VSS VSS gf180mcu_fd_sc_mcu7t5v0__nand3_1
XFILLER_57_300 VDD VDD VSS VSS gf180mcu_fd_sc_mcu7t5v0__fill_2
XFILLER_69_171 VDD VDD VSS VSS gf180mcu_fd_sc_mcu7t5v0__fillcap_8
XFILLER_72_325 VDD VDD VSS VSS gf180mcu_fd_sc_mcu7t5v0__fill_1
XFILLER_72_314 VDD VDD VSS VSS gf180mcu_fd_sc_mcu7t5v0__fill_1
XFILLER_84_174 VDD VDD VSS VSS gf180mcu_fd_sc_mcu7t5v0__fill_1
XTAP_TAPCELL_ROW_110_914 VDD VSS gf180mcu_fd_sc_mcu7t5v0__filltie
XFILLER_68_41 VDD VDD VSS VSS gf180mcu_fd_sc_mcu7t5v0__fill_1
XFILLER_95_417 VDD VDD VSS VSS gf180mcu_fd_sc_mcu7t5v0__fill_2
XFILLER_90_111 VDD VDD VSS VSS gf180mcu_fd_sc_mcu7t5v0__fill_1
XFILLER_90_122 VDD VDD VSS VSS gf180mcu_fd_sc_mcu7t5v0__fill_2
XFILLER_31_233 VDD VDD VSS VSS gf180mcu_fd_sc_mcu7t5v0__fillcap_16
X_2820_ wire31/Z _2819_/Z _2823_/A1 VDD VDD VSS VSS gf180mcu_fd_sc_mcu7t5v0__nor2_1
X_2751_ _3951_/Q _3893_/Q _2751_/Z VDD VDD VSS VSS gf180mcu_fd_sc_mcu7t5v0__xor2_1
XFILLER_76_4 VDD VDD VSS VSS gf180mcu_fd_sc_mcu7t5v0__fill_1
X_2682_ _2682_/A1 _2694_/A1 _2682_/A3 _2699_/A2 VDD VDD VSS VSS gf180mcu_fd_sc_mcu7t5v0__nor3_1
X_3303_ _3363_/B _3303_/A2 _3302_/Z _4041_/D VDD VDD VSS VSS gf180mcu_fd_sc_mcu7t5v0__nor3_1
X_3234_ _3234_/A1 _3240_/A2 _3234_/B _4011_/D VDD VDD VSS VSS gf180mcu_fd_sc_mcu7t5v0__aoi21_1
XFILLER_39_333 VDD VDD VSS VSS gf180mcu_fd_sc_mcu7t5v0__fill_1
X_3165_ wire90/I _3170_/A2 _3256_/B _3166_/B VDD VDD VSS VSS gf180mcu_fd_sc_mcu7t5v0__oai21_1
X_3096_ _3096_/A1 _3104_/A2 _3096_/B _3946_/D VDD VDD VSS VSS gf180mcu_fd_sc_mcu7t5v0__aoi21_1
X_2116_ _4040_/Q _2155_/A2 _2118_/A1 VDD VDD VSS VSS gf180mcu_fd_sc_mcu7t5v0__nor2_1
X_2047_ _3913_/Q _2684_/A2 VDD VDD VSS VSS gf180mcu_fd_sc_mcu7t5v0__clkinv_1
XFILLER_22_244 VDD VDD VSS VSS gf180mcu_fd_sc_mcu7t5v0__fill_1
X_3998_ _3998_/D _4166_/CLK _3998_/Q VDD VDD VSS VSS gf180mcu_fd_sc_mcu7t5v0__dffq_1
X_2949_ _2943_/Z _2958_/A2 _3015_/C1 VDD VDD VSS VSS gf180mcu_fd_sc_mcu7t5v0__nor2_1
XFILLER_13_69 VDD VDD VSS VSS gf180mcu_fd_sc_mcu7t5v0__fill_1
XFILLER_38_22 VDD VDD VSS VSS gf180mcu_fd_sc_mcu7t5v0__fillcap_4
XFILLER_60_317 VDD VDD VSS VSS gf180mcu_fd_sc_mcu7t5v0__fill_2
XFILLER_72_177 VDD VDD VSS VSS gf180mcu_fd_sc_mcu7t5v0__fillcap_32
XFILLER_9_204 VDD VDD VSS VSS gf180mcu_fd_sc_mcu7t5v0__fillcap_4
XFILLER_70_31 VDD VDD VSS VSS gf180mcu_fd_sc_mcu7t5v0__fillcap_4
XFILLER_70_53 VDD VDD VSS VSS gf180mcu_fd_sc_mcu7t5v0__fill_2
Xclkload18 _4052_/CLK clkload18/ZN VDD VDD VSS VSS gf180mcu_fd_sc_mcu7t5v0__clkinv_4
Xclkload29 _3548_/A2 clkload29/Z VDD VDD VSS VSS gf180mcu_fd_sc_mcu7t5v0__clkbuf_2
XFILLER_68_406 VDD VDD VSS VSS gf180mcu_fd_sc_mcu7t5v0__fillcap_4
XFILLER_95_72 VDD VDD VSS VSS gf180mcu_fd_sc_mcu7t5v0__fill_2
XFILLER_95_258 VDD VDD VSS VSS gf180mcu_fd_sc_mcu7t5v0__fill_2
XFILLER_36_314 VDD VDD VSS VSS gf180mcu_fd_sc_mcu7t5v0__fill_1
XFILLER_63_177 VDD VDD VSS VSS gf180mcu_fd_sc_mcu7t5v0__fill_2
XFILLER_63_188 VDD VDD VSS VSS gf180mcu_fd_sc_mcu7t5v0__fill_2
X_3921_ _3921_/D clkload2/I _3921_/Q VDD VDD VSS VSS gf180mcu_fd_sc_mcu7t5v0__dffq_1
XTAP_TAPCELL_ROW_74_695 VDD VSS gf180mcu_fd_sc_mcu7t5v0__filltie
X_3852_ _3852_/D clkload7/I _3852_/Q VDD VDD VSS VSS gf180mcu_fd_sc_mcu7t5v0__dffq_1
X_2803_ _3958_/Q _3900_/Q _3899_/Q _3957_/Q _2806_/A2 VDD VDD VSS VSS gf180mcu_fd_sc_mcu7t5v0__oai211_1
XFILLER_81_2 VDD VDD VSS VSS gf180mcu_fd_sc_mcu7t5v0__fill_2
X_3783_ _3783_/D _4104_/CLK _3783_/Q VDD VDD VSS VSS gf180mcu_fd_sc_mcu7t5v0__dffq_1
X_2734_ _2719_/I _2726_/Z _2749_/A3 VDD VDD VSS VSS gf180mcu_fd_sc_mcu7t5v0__nand2_1
XFILLER_117_146 VDD VDD VSS VSS gf180mcu_fd_sc_mcu7t5v0__fill_1
X_2665_ _3274_/A1 _3908_/Q _2691_/B VDD VDD VSS VSS gf180mcu_fd_sc_mcu7t5v0__nand2_1
X_2596_ _3990_/Q _2640_/A2 _2643_/B1 _3988_/Q _2596_/C _2597_/B VDD VDD VSS VSS gf180mcu_fd_sc_mcu7t5v0__aoi221_1
XFILLER_105_319 VDD VDD VSS VSS gf180mcu_fd_sc_mcu7t5v0__fill_2
XFILLER_59_417 VDD VDD VSS VSS gf180mcu_fd_sc_mcu7t5v0__fill_2
XFILLER_86_247 VDD VDD VSS VSS gf180mcu_fd_sc_mcu7t5v0__fill_2
X_4197_ _4197_/I _4197_/Z VDD VDD VSS VSS gf180mcu_fd_sc_mcu7t5v0__buf_1
X_3217_ _3217_/A1 _3217_/A2 _3217_/B _4003_/D VDD VDD VSS VSS gf180mcu_fd_sc_mcu7t5v0__aoi21_1
X_3148_ wire90/Z _3151_/A2 wire81/Z _3149_/B VDD VDD VSS VSS gf180mcu_fd_sc_mcu7t5v0__oai21_1
XTAP_TAPCELL_ROW_65_640 VDD VSS gf180mcu_fd_sc_mcu7t5v0__filltie
X_3079_ wire94/Z _3080_/A2 wire81/Z _3080_/B VDD VDD VSS VSS gf180mcu_fd_sc_mcu7t5v0__oai21_1
XFILLER_42_306 VDD VDD VSS VSS gf180mcu_fd_sc_mcu7t5v0__fill_1
XFILLER_54_177 VDD VDD VSS VSS gf180mcu_fd_sc_mcu7t5v0__fill_2
XFILLER_50_383 VDD VDD VSS VSS gf180mcu_fd_sc_mcu7t5v0__fill_2
XFILLER_10_247 VDD VDD VSS VSS gf180mcu_fd_sc_mcu7t5v0__fill_2
XFILLER_18_314 VDD VDD VSS VSS gf180mcu_fd_sc_mcu7t5v0__fill_1
XFILLER_18_303 VDD VDD VSS VSS gf180mcu_fd_sc_mcu7t5v0__fillcap_4
XTAP_TAPCELL_ROW_5_284 VDD VSS gf180mcu_fd_sc_mcu7t5v0__filltie
XFILLER_45_144 VDD VDD VSS VSS gf180mcu_fd_sc_mcu7t5v0__fill_1
XFILLER_60_103 VDD VDD VSS VSS gf180mcu_fd_sc_mcu7t5v0__fill_2
XFILLER_121_70 VDD VDD VSS VSS gf180mcu_fd_sc_mcu7t5v0__fillcap_8
XFILLER_60_136 VDD VDD VSS VSS gf180mcu_fd_sc_mcu7t5v0__fill_1
Xclkbuf_1_1__f__1476_ clkbuf_0__1476_/Z _3463_/A2 VDD VDD VSS VSS gf180mcu_fd_sc_mcu7t5v0__clkbuf_16
XTAP_TAPCELL_ROW_71_676 VDD VSS gf180mcu_fd_sc_mcu7t5v0__filltie
XPHY_EDGE_ROW_116_Right_116 VDD VSS gf180mcu_fd_sc_mcu7t5v0__endcap
X_2450_ _3862_/Q _2451_/A2 _2451_/B VDD VDD VSS VSS gf180mcu_fd_sc_mcu7t5v0__nand2_1
XFILLER_53_6 VDD VDD VSS VSS gf180mcu_fd_sc_mcu7t5v0__fill_1
XFILLER_107_190 VDD VDD VSS VSS gf180mcu_fd_sc_mcu7t5v0__fill_1
X_2381_ _2495_/C _2379_/Z _2549_/A2 VDD VDD VSS VSS gf180mcu_fd_sc_mcu7t5v0__nand2_1
X_4120_ _4120_/D _4149_/CLK _4120_/Q VDD VDD VSS VSS gf180mcu_fd_sc_mcu7t5v0__dffq_1
X_4051_ _4051_/D _4052_/CLK _4051_/Q VDD VDD VSS VSS gf180mcu_fd_sc_mcu7t5v0__dffq_1
X_3002_ _3949_/Q _3012_/A2 _3105_/A1 _3957_/Q _3007_/A1 VDD VDD VSS VSS gf180mcu_fd_sc_mcu7t5v0__aoi22_1
XFILLER_36_100 VDD VDD VSS VSS gf180mcu_fd_sc_mcu7t5v0__fillcap_4
Xinput5 i2c_sda_in input5/Z VDD VDD VSS VSS gf180mcu_fd_sc_mcu7t5v0__dlyb_1
XFILLER_36_144 VDD VDD VSS VSS gf180mcu_fd_sc_mcu7t5v0__fillcap_16
Xclkbuf_leaf_1__1473_ clkbuf_leaf_5__1473_/I _3479_/A2 VDD VDD VSS VSS gf180mcu_fd_sc_mcu7t5v0__clkbuf_8
XFILLER_24_317 VDD VDD VSS VSS gf180mcu_fd_sc_mcu7t5v0__fillcap_64
XFILLER_24_306 VDD VDD VSS VSS gf180mcu_fd_sc_mcu7t5v0__fillcap_8
XTAP_TAPCELL_ROW_19_364 VDD VSS gf180mcu_fd_sc_mcu7t5v0__filltie
XFILLER_36_177 VDD VDD VSS VSS gf180mcu_fd_sc_mcu7t5v0__fillcap_16
XFILLER_91_250 VDD VDD VSS VSS gf180mcu_fd_sc_mcu7t5v0__fill_1
XFILLER_101_18 VDD VDD VSS VSS gf180mcu_fd_sc_mcu7t5v0__fillcap_4
X_3904_ _3904_/D _4034_/CLK _3904_/Q VDD VDD VSS VSS gf180mcu_fd_sc_mcu7t5v0__dffq_1
XFILLER_32_372 VDD VDD VSS VSS gf180mcu_fd_sc_mcu7t5v0__fill_2
X_3835_ _3835_/D clkload8/I _3835_/Q VDD VDD VSS VSS gf180mcu_fd_sc_mcu7t5v0__dffq_1
X_3766_ _3766_/D _4142_/CLK _3766_/Q VDD VDD VSS VSS gf180mcu_fd_sc_mcu7t5v0__dffq_1
X_2717_ _2760_/C _2716_/Z _3888_/D VDD VDD VSS VSS gf180mcu_fd_sc_mcu7t5v0__nor2_1
X_3697_ _3854_/Q _3678_/Z _3698_/B VDD VDD VSS VSS gf180mcu_fd_sc_mcu7t5v0__nand2_1
X_2648_ _2648_/A1 _2648_/A2 _2648_/B _2699_/A1 VDD VDD VSS VSS gf180mcu_fd_sc_mcu7t5v0__oai21_1
X_2579_ _2579_/A1 _2579_/A2 _2579_/B _2590_/A1 VDD VDD VSS VSS gf180mcu_fd_sc_mcu7t5v0__oai21_1
XFILLER_101_388 VDD VDD VSS VSS gf180mcu_fd_sc_mcu7t5v0__fillcap_4
XTAP_TAPCELL_ROW_2_265 VDD VSS gf180mcu_fd_sc_mcu7t5v0__filltie
XTAP_TAPCELL_ROW_105_880 VDD VSS gf180mcu_fd_sc_mcu7t5v0__filltie
XFILLER_50_191 VDD VDD VSS VSS gf180mcu_fd_sc_mcu7t5v0__fill_1
XFILLER_109_422 VDD VDD VSS VSS gf180mcu_fd_sc_mcu7t5v0__fillcap_4
XFILLER_51_88 VDD VDD VSS VSS gf180mcu_fd_sc_mcu7t5v0__fillcap_32
XFILLER_2_265 VDD VDD VSS VSS gf180mcu_fd_sc_mcu7t5v0__fill_2
XFILLER_73_261 VDD VDD VSS VSS gf180mcu_fd_sc_mcu7t5v0__fill_1
XPHY_EDGE_ROW_1_Left_123 VDD VSS gf180mcu_fd_sc_mcu7t5v0__endcap
XFILLER_14_372 VDD VDD VSS VSS gf180mcu_fd_sc_mcu7t5v0__fillcap_8
X_1950_ _3995_/Q _3200_/A1 VDD VDD VSS VSS gf180mcu_fd_sc_mcu7t5v0__clkinv_1
X_1881_ _4135_/Q _3709_/A1 VDD VDD VSS VSS gf180mcu_fd_sc_mcu7t5v0__clkinv_1
X_3620_ _4134_/Q _3700_/A1 _3679_/A1 _4126_/Q _3620_/C1 _3667_/C2 _3621_/A2 VDD VDD
+ VSS VSS gf180mcu_fd_sc_mcu7t5v0__aoi222_1
X_3551_ _4146_/Q _3551_/A2 _3551_/B1 _4105_/Q _3552_/A2 VDD VDD VSS VSS gf180mcu_fd_sc_mcu7t5v0__aoi22_1
X_2502_ _3884_/Q _3883_/Q _2502_/B _2504_/A2 VDD VDD VSS VSS gf180mcu_fd_sc_mcu7t5v0__oai21_1
X_3482_ _4084_/Q _3474_/Z _4085_/Q _3483_/A2 VDD VDD VSS VSS gf180mcu_fd_sc_mcu7t5v0__aoi21_1
X_2433_ _2457_/A1 _2430_/Z _2433_/B _3855_/D VDD VDD VSS VSS gf180mcu_fd_sc_mcu7t5v0__aoi21_1
XPHY_EDGE_ROW_47_Left_169 VDD VSS gf180mcu_fd_sc_mcu7t5v0__endcap
X_2364_ hold223/Z _2372_/S _2365_/B VDD VDD VSS VSS gf180mcu_fd_sc_mcu7t5v0__nand2_1
XTAP_TAPCELL_ROW_99_849 VDD VSS gf180mcu_fd_sc_mcu7t5v0__filltie
X_4103_ _4103_/D _4104_/CLK _4103_/Q VDD VDD VSS VSS gf180mcu_fd_sc_mcu7t5v0__dffq_1
X_2295_ _3807_/Q _2300_/S _2296_/B VDD VDD VSS VSS gf180mcu_fd_sc_mcu7t5v0__nand2_1
XFILLER_49_291 VDD VDD VSS VSS gf180mcu_fd_sc_mcu7t5v0__fill_1
X_4034_ _4034_/D _4034_/CLK _4034_/Q VDD VDD VSS VSS gf180mcu_fd_sc_mcu7t5v0__dffq_1
XPHY_EDGE_ROW_56_Left_178 VDD VSS gf180mcu_fd_sc_mcu7t5v0__endcap
XTAP_TAPCELL_ROW_90_793 VDD VSS gf180mcu_fd_sc_mcu7t5v0__filltie
X_3818_ _3818_/D clkload6/I _3818_/Q VDD VDD VSS VSS gf180mcu_fd_sc_mcu7t5v0__dffq_1
XFILLER_21_14 VDD VDD VSS VSS gf180mcu_fd_sc_mcu7t5v0__fillcap_4
XFILLER_21_69 VDD VDD VSS VSS gf180mcu_fd_sc_mcu7t5v0__fill_1
XFILLER_21_47 VDD VDD VSS VSS gf180mcu_fd_sc_mcu7t5v0__fillcap_16
X_3749_ hold180/Z wire94/Z _3757_/S _4148_/D VDD VDD VSS VSS gf180mcu_fd_sc_mcu7t5v0__mux2_2
XPHY_EDGE_ROW_65_Left_187 VDD VSS gf180mcu_fd_sc_mcu7t5v0__endcap
XFILLER_106_425 VDD VDD VSS VSS gf180mcu_fd_sc_mcu7t5v0__fill_1
XFILLER_28_420 VDD VDD VSS VSS gf180mcu_fd_sc_mcu7t5v0__fillcap_4
Xmax_cap34 _2373_/S _2372_/S VDD VDD VSS VSS gf180mcu_fd_sc_mcu7t5v0__clkbuf_3
Xmax_cap45 _3172_/A2 _3170_/A2 VDD VDD VSS VSS gf180mcu_fd_sc_mcu7t5v0__clkbuf_3
XPHY_EDGE_ROW_74_Left_196 VDD VSS gf180mcu_fd_sc_mcu7t5v0__endcap
XTAP_TAPCELL_ROW_38_481 VDD VSS gf180mcu_fd_sc_mcu7t5v0__filltie
Xmax_cap67 _3005_/A2 _3224_/A1 VDD VDD VSS VSS gf180mcu_fd_sc_mcu7t5v0__buf_2
Xmax_cap56 _3629_/C2 _3748_/A1 VDD VDD VSS VSS gf180mcu_fd_sc_mcu7t5v0__buf_2
Xmax_cap78 _3395_/A1 _3363_/B VDD VDD VSS VSS gf180mcu_fd_sc_mcu7t5v0__buf_4
Xmax_cap89 _3852_/Q _3286_/A1 VDD VDD VSS VSS gf180mcu_fd_sc_mcu7t5v0__buf_4
XFILLER_30_139 VDD VDD VSS VSS gf180mcu_fd_sc_mcu7t5v0__fill_1
XTAP_TAPCELL_ROW_21_381 VDD VSS gf180mcu_fd_sc_mcu7t5v0__filltie
XFILLER_7_346 VDD VDD VSS VSS gf180mcu_fd_sc_mcu7t5v0__fillcap_4
X_2080_ _2376_/A1 hold124/Z _4158_/D VDD VDD VSS VSS gf180mcu_fd_sc_mcu7t5v0__nor2_1
XFILLER_53_209 VDD VDD VSS VSS gf180mcu_fd_sc_mcu7t5v0__fill_1
XFILLER_34_423 VDD VDD VSS VSS gf180mcu_fd_sc_mcu7t5v0__fill_2
X_2982_ _3971_/Q _3139_/A1 _3060_/A1 _3934_/Q _2988_/A1 VDD VDD VSS VSS gf180mcu_fd_sc_mcu7t5v0__aoi22_1
X_1933_ _1933_/I _3236_/A1 VDD VDD VSS VSS gf180mcu_fd_sc_mcu7t5v0__clkinv_1
X_3603_ _3603_/A1 _3603_/A2 _3604_/B2 VDD VDD VSS VSS gf180mcu_fd_sc_mcu7t5v0__nand2_1
X_3534_ _4097_/Q _3527_/B _3534_/B _3535_/A3 VDD VDD VSS VSS gf180mcu_fd_sc_mcu7t5v0__aoi21_1
X_3465_ _4080_/Q _3465_/A2 _3465_/B _4080_/D VDD VDD VSS VSS gf180mcu_fd_sc_mcu7t5v0__aoi21_1
X_2416_ _3852_/Q wire51/Z wire77/Z _3812_/Q _2417_/I VDD VDD VSS VSS gf180mcu_fd_sc_mcu7t5v0__aoi22_1
X_3396_ _4105_/Q _3396_/A2 _4064_/Q _3399_/A2 VDD VDD VSS VSS gf180mcu_fd_sc_mcu7t5v0__aoi21_1
X_2347_ _3834_/Q _2331_/B _2347_/B1 _2333_/B _2348_/A2 VDD VDD VSS VSS gf180mcu_fd_sc_mcu7t5v0__oai22_1
X_2278_ _2278_/I _2290_/A2 VDD VDD VSS VSS gf180mcu_fd_sc_mcu7t5v0__clkinv_1
X_4017_ _4017_/D _4017_/CLK _4017_/Q VDD VDD VSS VSS gf180mcu_fd_sc_mcu7t5v0__dffq_1
XTAP_TAPCELL_ROW_35_462 VDD VSS gf180mcu_fd_sc_mcu7t5v0__filltie
XFILLER_32_46 VDD VDD VSS VSS gf180mcu_fd_sc_mcu7t5v0__fill_2
XFILLER_120_6 VDD VDD VSS VSS gf180mcu_fd_sc_mcu7t5v0__fill_2
XFILLER_106_255 VDD VDD VSS VSS gf180mcu_fd_sc_mcu7t5v0__fillcap_4
XFILLER_79_139 VDD VDD VSS VSS gf180mcu_fd_sc_mcu7t5v0__fill_1
XFILLER_87_172 VDD VDD VSS VSS gf180mcu_fd_sc_mcu7t5v0__fillcap_8
XPHY_EDGE_ROW_82_Left_204 VDD VSS gf180mcu_fd_sc_mcu7t5v0__endcap
XFILLER_16_423 VDD VDD VSS VSS gf180mcu_fd_sc_mcu7t5v0__fill_2
XTAP_TAPCELL_ROW_58_598 VDD VSS gf180mcu_fd_sc_mcu7t5v0__filltie
XFILLER_113_93 VDD VDD VSS VSS gf180mcu_fd_sc_mcu7t5v0__fillcap_4
XPHY_EDGE_ROW_91_Left_213 VDD VSS gf180mcu_fd_sc_mcu7t5v0__endcap
XTAP_TAPCELL_ROW_41_498 VDD VSS gf180mcu_fd_sc_mcu7t5v0__filltie
X_3250_ wire90/I _3257_/A2 _3256_/B _3251_/B VDD VDD VSS VSS gf180mcu_fd_sc_mcu7t5v0__oai21_1
X_3181_ _3181_/A1 wire44/Z _3181_/B _3986_/D VDD VDD VSS VSS gf180mcu_fd_sc_mcu7t5v0__aoi21_1
X_2201_ _3787_/Q _2111_/Z _3746_/B _2202_/A2 VDD VDD VSS VSS gf180mcu_fd_sc_mcu7t5v0__oai21_1
X_2132_ _3764_/Q _2243_/A2 _3746_/B _2133_/A2 VDD VDD VSS VSS gf180mcu_fd_sc_mcu7t5v0__oai21_1
X_2063_ _3895_/Q _2776_/A2 VDD VDD VSS VSS gf180mcu_fd_sc_mcu7t5v0__clkinv_1
XTAP_TAPCELL_ROW_32_443 VDD VSS gf180mcu_fd_sc_mcu7t5v0__filltie
X_2965_ _4017_/Q _3036_/A2 _3013_/B1 _3993_/Q _2966_/A4 VDD VDD VSS VSS gf180mcu_fd_sc_mcu7t5v0__aoi22_1
X_2896_ _3145_/A1 _2896_/A2 _2896_/B _2897_/B1 VDD VDD VSS VSS gf180mcu_fd_sc_mcu7t5v0__oai21_1
X_1916_ _4029_/Q _3272_/A1 VDD VDD VSS VSS gf180mcu_fd_sc_mcu7t5v0__clkinv_1
X_3517_ _4093_/Q _3527_/B _3536_/A2 _3523_/A2 _3519_/A1 VDD VDD VSS VSS gf180mcu_fd_sc_mcu7t5v0__aoi22_1
X_3448_ _4094_/Q _4093_/Q _3520_/A1 VDD VDD VSS VSS gf180mcu_fd_sc_mcu7t5v0__nand2_1
XFILLER_103_247 VDD VDD VSS VSS gf180mcu_fd_sc_mcu7t5v0__fill_2
X_3379_ _4139_/Q _4079_/Q _3379_/Z VDD VDD VSS VSS gf180mcu_fd_sc_mcu7t5v0__xor2_1
XFILLER_69_183 VDD VDD VSS VSS gf180mcu_fd_sc_mcu7t5v0__fill_2
XFILLER_84_153 VDD VDD VSS VSS gf180mcu_fd_sc_mcu7t5v0__fill_1
XTAP_TAPCELL_ROW_110_915 VDD VSS gf180mcu_fd_sc_mcu7t5v0__filltie
XFILLER_43_67 VDD VDD VSS VSS gf180mcu_fd_sc_mcu7t5v0__fill_2
XFILLER_43_89 VDD VDD VSS VSS gf180mcu_fd_sc_mcu7t5v0__fillcap_32
XFILLER_68_31 VDD VDD VSS VSS gf180mcu_fd_sc_mcu7t5v0__fillcap_4
XFILLER_75_131 VDD VDD VSS VSS gf180mcu_fd_sc_mcu7t5v0__fill_1
XFILLER_16_253 VDD VDD VSS VSS gf180mcu_fd_sc_mcu7t5v0__fillcap_8
XFILLER_31_212 VDD VDD VSS VSS gf180mcu_fd_sc_mcu7t5v0__fill_2
X_2750_ _2741_/Z _2750_/A2 _2750_/A3 _2750_/Z VDD VDD VSS VSS gf180mcu_fd_sc_mcu7t5v0__and3_1
X_2681_ _2689_/B _2681_/A2 _2681_/A3 _2680_/Z _2682_/A3 VDD VDD VSS VSS gf180mcu_fd_sc_mcu7t5v0__nand4_1
X_3302_ _3398_/A3 _4041_/Q _4040_/Q _4039_/Q _3302_/Z VDD VDD VSS VSS gf180mcu_fd_sc_mcu7t5v0__and4_1
X_3233_ wire90/I _3240_/A2 wire81/I _3234_/B VDD VDD VSS VSS gf180mcu_fd_sc_mcu7t5v0__oai21_1
X_3164_ _3164_/A1 _3170_/A2 _3164_/B _3978_/D VDD VDD VSS VSS gf180mcu_fd_sc_mcu7t5v0__aoi21_1
XFILLER_39_356 VDD VDD VSS VSS gf180mcu_fd_sc_mcu7t5v0__fill_2
X_3095_ wire91/I _3104_/A2 wire81/I _3096_/B VDD VDD VSS VSS gf180mcu_fd_sc_mcu7t5v0__oai21_1
X_2115_ _2115_/A1 _2115_/A2 hold168/I VDD VDD VSS VSS gf180mcu_fd_sc_mcu7t5v0__nor2_1
X_2046_ _3914_/Q _2910_/A2 VDD VDD VSS VSS gf180mcu_fd_sc_mcu7t5v0__clkinv_1
XFILLER_120_17 VDD VDD VSS VSS gf180mcu_fd_sc_mcu7t5v0__fillcap_8
X_3997_ _3997_/D _4149_/CLK _3997_/Q VDD VDD VSS VSS gf180mcu_fd_sc_mcu7t5v0__dffq_1
XFILLER_13_48 VDD VDD VSS VSS gf180mcu_fd_sc_mcu7t5v0__fill_1
X_2948_ _2958_/A2 _2947_/Z _3036_/B1 VDD VDD VSS VSS gf180mcu_fd_sc_mcu7t5v0__nor2_1
XFILLER_108_317 VDD VDD VSS VSS gf180mcu_fd_sc_mcu7t5v0__fillcap_4
X_2879_ _3969_/Q _3911_/Q _2885_/B VDD VDD VSS VSS gf180mcu_fd_sc_mcu7t5v0__xor2_1
XFILLER_116_383 VDD VDD VSS VSS gf180mcu_fd_sc_mcu7t5v0__fill_2
XFILLER_1_116 VDD VDD VSS VSS gf180mcu_fd_sc_mcu7t5v0__fill_2
XTAP_TAPCELL_ROW_68_660 VDD VSS gf180mcu_fd_sc_mcu7t5v0__filltie
XTAP_TAPCELL_ROW_51_560 VDD VSS gf180mcu_fd_sc_mcu7t5v0__filltie
XFILLER_5_422 VDD VDD VSS VSS gf180mcu_fd_sc_mcu7t5v0__fillcap_4
Xclkload19 _4058_/CLK clkload19/ZN VDD VDD VSS VSS gf180mcu_fd_sc_mcu7t5v0__inv_2
XFILLER_79_96 VDD VDD VSS VSS gf180mcu_fd_sc_mcu7t5v0__fillcap_4
XFILLER_48_164 VDD VDD VSS VSS gf180mcu_fd_sc_mcu7t5v0__fillcap_4
X_3920_ _3920_/D clkload2/I _3920_/Q VDD VDD VSS VSS gf180mcu_fd_sc_mcu7t5v0__dffq_1
XTAP_TAPCELL_ROW_74_696 VDD VSS gf180mcu_fd_sc_mcu7t5v0__filltie
X_3851_ _3851_/D clkload7/I wire90/I VDD VDD VSS VSS gf180mcu_fd_sc_mcu7t5v0__dffq_1
X_2802_ _2791_/C _2791_/B _2802_/A3 _2802_/A4 _2804_/B VDD VDD VSS VSS gf180mcu_fd_sc_mcu7t5v0__nor4_1
X_3782_ _3782_/D _4104_/CLK _3782_/Q VDD VDD VSS VSS gf180mcu_fd_sc_mcu7t5v0__dffq_1
X_2733_ _3948_/Q _3890_/Q _3889_/Q _3947_/Q _2735_/A2 VDD VDD VSS VSS gf180mcu_fd_sc_mcu7t5v0__aoi22_1
XFILLER_74_2 VDD VDD VSS VSS gf180mcu_fd_sc_mcu7t5v0__fill_2
X_2664_ _3270_/A1 _3906_/Q _2689_/B VDD VDD VSS VSS gf180mcu_fd_sc_mcu7t5v0__nand2_1
X_2595_ _3989_/Q _3899_/Q _2596_/C VDD VDD VSS VSS gf180mcu_fd_sc_mcu7t5v0__xor2_1
XFILLER_113_331 VDD VDD VSS VSS gf180mcu_fd_sc_mcu7t5v0__fill_2
X_4196_ _4196_/I _4196_/Z VDD VDD VSS VSS gf180mcu_fd_sc_mcu7t5v0__buf_1
XFILLER_39_142 VDD VDD VSS VSS gf180mcu_fd_sc_mcu7t5v0__fillcap_4
X_3216_ wire90/Z _3217_/A2 wire81/Z _3217_/B VDD VDD VSS VSS gf180mcu_fd_sc_mcu7t5v0__oai21_1
X_3147_ _3147_/A1 _3151_/A2 _3147_/B _3970_/D VDD VDD VSS VSS gf180mcu_fd_sc_mcu7t5v0__aoi21_1
XTAP_TAPCELL_ROW_65_641 VDD VSS gf180mcu_fd_sc_mcu7t5v0__filltie
X_3078_ _3078_/A1 _3082_/A2 _3078_/B _3938_/D VDD VDD VSS VSS gf180mcu_fd_sc_mcu7t5v0__aoi21_1
X_2029_ _3824_/Q _2292_/A1 VDD VDD VSS VSS gf180mcu_fd_sc_mcu7t5v0__clkinv_1
XFILLER_24_47 VDD VDD VSS VSS gf180mcu_fd_sc_mcu7t5v0__fill_1
XFILLER_10_226 VDD VDD VSS VSS gf180mcu_fd_sc_mcu7t5v0__fill_2
XFILLER_40_68 VDD VDD VSS VSS gf180mcu_fd_sc_mcu7t5v0__fill_1
XFILLER_2_425 VDD VDD VSS VSS gf180mcu_fd_sc_mcu7t5v0__fill_1
XFILLER_104_375 VDD VDD VSS VSS gf180mcu_fd_sc_mcu7t5v0__fillcap_4
XFILLER_1_18 VDD VDD VSS VSS gf180mcu_fd_sc_mcu7t5v0__fillcap_8
XTAP_TAPCELL_ROW_5_285 VDD VSS gf180mcu_fd_sc_mcu7t5v0__filltie
XFILLER_105_72 VDD VDD VSS VSS gf180mcu_fd_sc_mcu7t5v0__fillcap_4
XFILLER_65_54 VDD VDD VSS VSS gf180mcu_fd_sc_mcu7t5v0__fillcap_16
XFILLER_85_292 VDD VDD VSS VSS gf180mcu_fd_sc_mcu7t5v0__fill_1
XFILLER_60_115 VDD VDD VSS VSS gf180mcu_fd_sc_mcu7t5v0__fill_1
XFILLER_121_82 VDD VDD VSS VSS gf180mcu_fd_sc_mcu7t5v0__fill_2
XTAP_TAPCELL_ROW_71_677 VDD VSS gf180mcu_fd_sc_mcu7t5v0__filltie
XFILLER_5_263 VDD VDD VSS VSS gf180mcu_fd_sc_mcu7t5v0__fill_2
X_2380_ _2495_/C _2379_/Z _2380_/Z VDD VDD VSS VSS gf180mcu_fd_sc_mcu7t5v0__and2_1
X_4050_ _4050_/D _4052_/CLK _4050_/Q VDD VDD VSS VSS gf180mcu_fd_sc_mcu7t5v0__dffq_1
X_3001_ _3965_/Q _3036_/B1 _3015_/C1 _3973_/Q _3008_/A1 VDD VDD VSS VSS gf180mcu_fd_sc_mcu7t5v0__aoi22_1
XFILLER_76_281 VDD VDD VSS VSS gf180mcu_fd_sc_mcu7t5v0__fill_1
XTAP_TAPCELL_ROW_19_365 VDD VSS gf180mcu_fd_sc_mcu7t5v0__filltie
XTAP_TAPCELL_ROW_62_622 VDD VSS gf180mcu_fd_sc_mcu7t5v0__filltie
X_3903_ _3903_/D _4034_/CLK _3903_/Q VDD VDD VSS VSS gf180mcu_fd_sc_mcu7t5v0__dffq_1
X_3834_ _3834_/D clkload8/I _3834_/Q VDD VDD VSS VSS gf180mcu_fd_sc_mcu7t5v0__dffq_1
XFILLER_118_423 VDD VDD VSS VSS gf180mcu_fd_sc_mcu7t5v0__fill_2
X_3765_ _3765_/D _4052_/CLK _3765_/Q VDD VDD VSS VSS gf180mcu_fd_sc_mcu7t5v0__dffq_1
X_2716_ _3946_/Q _2716_/A2 _2716_/A3 _2716_/Z VDD VDD VSS VSS gf180mcu_fd_sc_mcu7t5v0__xor3_1
X_3696_ _3696_/A1 _3678_/Z _3696_/B _3746_/B _4130_/D VDD VDD VSS VSS gf180mcu_fd_sc_mcu7t5v0__oai211_1
X_2647_ _3257_/A1 _3900_/Q _2647_/B _2648_/B VDD VDD VSS VSS gf180mcu_fd_sc_mcu7t5v0__oai21_1
X_2578_ _3981_/Q _2746_/A2 _2633_/C1 _3980_/Q _2579_/B VDD VDD VSS VSS gf180mcu_fd_sc_mcu7t5v0__aoi22_1
XFILLER_113_172 VDD VDD VSS VSS gf180mcu_fd_sc_mcu7t5v0__fillcap_8
XFILLER_101_356 VDD VDD VSS VSS gf180mcu_fd_sc_mcu7t5v0__fill_2
XFILLER_19_69 VDD VDD VSS VSS gf180mcu_fd_sc_mcu7t5v0__fill_1
XFILLER_27_134 VDD VDD VSS VSS gf180mcu_fd_sc_mcu7t5v0__fillcap_4
XTAP_TAPCELL_ROW_2_266 VDD VSS gf180mcu_fd_sc_mcu7t5v0__filltie
XFILLER_42_104 VDD VDD VSS VSS gf180mcu_fd_sc_mcu7t5v0__fill_1
XFILLER_35_68 VDD VDD VSS VSS gf180mcu_fd_sc_mcu7t5v0__fill_2
XTAP_TAPCELL_ROW_105_881 VDD VSS gf180mcu_fd_sc_mcu7t5v0__filltie
XPHY_EDGE_ROW_14_Right_14 VDD VSS gf180mcu_fd_sc_mcu7t5v0__endcap
XFILLER_50_170 VDD VDD VSS VSS gf180mcu_fd_sc_mcu7t5v0__fillcap_4
XFILLER_50_181 VDD VDD VSS VSS gf180mcu_fd_sc_mcu7t5v0__fill_2
XFILLER_51_34 VDD VDD VSS VSS gf180mcu_fd_sc_mcu7t5v0__fillcap_4
XFILLER_2_244 VDD VDD VSS VSS gf180mcu_fd_sc_mcu7t5v0__fill_1
XFILLER_4_2 VDD VDD VSS VSS gf180mcu_fd_sc_mcu7t5v0__fillcap_4
XPHY_EDGE_ROW_23_Right_23 VDD VSS gf180mcu_fd_sc_mcu7t5v0__endcap
XFILLER_65_207 VDD VDD VSS VSS gf180mcu_fd_sc_mcu7t5v0__fill_2
XFILLER_65_229 VDD VDD VSS VSS gf180mcu_fd_sc_mcu7t5v0__fillcap_4
XFILLER_18_145 VDD VDD VSS VSS gf180mcu_fd_sc_mcu7t5v0__fill_1
XTAP_TAPCELL_ROW_16_346 VDD VSS gf180mcu_fd_sc_mcu7t5v0__filltie
XFILLER_14_340 VDD VDD VSS VSS gf180mcu_fd_sc_mcu7t5v0__fillcap_32
XPHY_EDGE_ROW_32_Right_32 VDD VSS gf180mcu_fd_sc_mcu7t5v0__endcap
XFILLER_33_137 VDD VDD VSS VSS gf180mcu_fd_sc_mcu7t5v0__fill_2
XFILLER_92_85 VDD VDD VSS VSS gf180mcu_fd_sc_mcu7t5v0__fillcap_4
XFILLER_14_384 VDD VDD VSS VSS gf180mcu_fd_sc_mcu7t5v0__fill_1
X_1880_ _4136_/Q _3711_/A1 VDD VDD VSS VSS gf180mcu_fd_sc_mcu7t5v0__clkinv_1
X_3550_ _4105_/Q _3550_/A2 _3552_/B VDD VDD VSS VSS gf180mcu_fd_sc_mcu7t5v0__nor2_1
X_2501_ _3882_/Q _2549_/B _2502_/B VDD VDD VSS VSS gf180mcu_fd_sc_mcu7t5v0__nand2_1
X_3481_ _4085_/Q _4084_/Q _3474_/Z _3481_/Z VDD VDD VSS VSS gf180mcu_fd_sc_mcu7t5v0__and3_1
XPHY_EDGE_ROW_41_Right_41 VDD VSS gf180mcu_fd_sc_mcu7t5v0__endcap
X_2432_ _3855_/Q _2430_/Z _3746_/B _2433_/B VDD VDD VSS VSS gf180mcu_fd_sc_mcu7t5v0__oai21_1
X_2363_ _3833_/Q _2363_/A2 _2363_/A3 _2373_/S VDD VDD VSS VSS gf180mcu_fd_sc_mcu7t5v0__nand3_1
XFILLER_96_310 VDD VDD VSS VSS gf180mcu_fd_sc_mcu7t5v0__fillcap_4
XFILLER_96_321 VDD VDD VSS VSS gf180mcu_fd_sc_mcu7t5v0__fill_2
XPHY_EDGE_ROW_102_Left_224 VDD VSS gf180mcu_fd_sc_mcu7t5v0__endcap
X_4102_ _4102_/D _4142_/CLK _4102_/Q VDD VDD VSS VSS gf180mcu_fd_sc_mcu7t5v0__dffq_1
XFILLER_96_332 VDD VDD VSS VSS gf180mcu_fd_sc_mcu7t5v0__fill_2
X_4033_ _4033_/D _4034_/CLK _4033_/Q VDD VDD VSS VSS gf180mcu_fd_sc_mcu7t5v0__dffq_1
X_2294_ _2322_/A1 _2363_/A3 _2296_/A2 VDD VDD VSS VSS gf180mcu_fd_sc_mcu7t5v0__nand2_1
XFILLER_110_197 VDD VDD VSS VSS gf180mcu_fd_sc_mcu7t5v0__fillcap_8
XFILLER_24_104 VDD VDD VSS VSS gf180mcu_fd_sc_mcu7t5v0__fill_1
XPHY_EDGE_ROW_50_Right_50 VDD VSS gf180mcu_fd_sc_mcu7t5v0__endcap
XPHY_EDGE_ROW_111_Left_233 VDD VSS gf180mcu_fd_sc_mcu7t5v0__endcap
XFILLER_24_148 VDD VDD VSS VSS gf180mcu_fd_sc_mcu7t5v0__fillcap_4
XFILLER_32_181 VDD VDD VSS VSS gf180mcu_fd_sc_mcu7t5v0__fill_1
XTAP_TAPCELL_ROW_90_794 VDD VSS gf180mcu_fd_sc_mcu7t5v0__filltie
XTAP_TAPCELL_ROW_102_862 VDD VSS gf180mcu_fd_sc_mcu7t5v0__filltie
XFILLER_20_365 VDD VDD VSS VSS gf180mcu_fd_sc_mcu7t5v0__fillcap_16
X_3817_ _3817_/D clkload6/I _3817_/Q VDD VDD VSS VSS gf180mcu_fd_sc_mcu7t5v0__dffq_1
XFILLER_20_387 VDD VDD VSS VSS gf180mcu_fd_sc_mcu7t5v0__fillcap_32
X_3748_ _3748_/A1 _3748_/A2 _3757_/S VDD VDD VSS VSS gf180mcu_fd_sc_mcu7t5v0__and2_1
XPHY_EDGE_ROW_120_Left_242 VDD VSS gf180mcu_fd_sc_mcu7t5v0__endcap
X_3679_ _3679_/A1 _3748_/A2 _3692_/A2 VDD VDD VSS VSS gf180mcu_fd_sc_mcu7t5v0__nand2_1
Xclkbuf_0__1477_ _3463_/ZN clkbuf_0__1477_/Z VDD VDD VSS VSS gf180mcu_fd_sc_mcu7t5v0__clkbuf_16
XFILLER_99_181 VDD VDD VSS VSS gf180mcu_fd_sc_mcu7t5v0__fill_2
XFILLER_101_153 VDD VDD VSS VSS gf180mcu_fd_sc_mcu7t5v0__fillcap_4
XFILLER_101_142 VDD VDD VSS VSS gf180mcu_fd_sc_mcu7t5v0__fill_2
XFILLER_46_34 VDD VDD VSS VSS gf180mcu_fd_sc_mcu7t5v0__fill_1
Xmax_cap35 _2296_/A2 _2300_/S VDD VDD VSS VSS gf180mcu_fd_sc_mcu7t5v0__buf_3
XFILLER_46_45 VDD VDD VSS VSS gf180mcu_fd_sc_mcu7t5v0__fillcap_4
Xmax_cap46 _3155_/A2 _3151_/A2 VDD VDD VSS VSS gf180mcu_fd_sc_mcu7t5v0__buf_4
Xmax_cap68 _2475_/A2 _2495_/A2 VDD VDD VSS VSS gf180mcu_fd_sc_mcu7t5v0__buf_2
XFILLER_15_104 VDD VDD VSS VSS gf180mcu_fd_sc_mcu7t5v0__fillcap_4
XTAP_TAPCELL_ROW_38_482 VDD VSS gf180mcu_fd_sc_mcu7t5v0__filltie
XFILLER_55_262 VDD VDD VSS VSS gf180mcu_fd_sc_mcu7t5v0__fill_2
XFILLER_55_284 VDD VDD VSS VSS gf180mcu_fd_sc_mcu7t5v0__fill_1
Xmax_cap57 _3588_/A3 _3669_/A2 VDD VDD VSS VSS gf180mcu_fd_sc_mcu7t5v0__buf_2
XFILLER_70_254 VDD VDD VSS VSS gf180mcu_fd_sc_mcu7t5v0__fillcap_16
XFILLER_102_62 VDD VDD VSS VSS gf180mcu_fd_sc_mcu7t5v0__fillcap_4
XFILLER_30_107 VDD VDD VSS VSS gf180mcu_fd_sc_mcu7t5v0__fillcap_16
XFILLER_62_77 VDD VDD VSS VSS gf180mcu_fd_sc_mcu7t5v0__fill_1
XFILLER_87_52 VDD VDD VSS VSS gf180mcu_fd_sc_mcu7t5v0__fill_2
XFILLER_87_96 VDD VDD VSS VSS gf180mcu_fd_sc_mcu7t5v0__fillcap_4
XFILLER_93_346 VDD VDD VSS VSS gf180mcu_fd_sc_mcu7t5v0__fillcap_4
X_2981_ _3963_/Q _3122_/A1 _3207_/A1 _4003_/Q _2984_/A2 VDD VDD VSS VSS gf180mcu_fd_sc_mcu7t5v0__aoi22_1
X_1932_ _1932_/I _3238_/A1 VDD VDD VSS VSS gf180mcu_fd_sc_mcu7t5v0__clkinv_1
X_3602_ _3667_/C2 _3602_/A2 _3638_/A2 _4124_/Q _4140_/Q _3723_/A2 _3603_/A2 VDD VDD
+ VSS VSS gf180mcu_fd_sc_mcu7t5v0__aoi222_1
XFILLER_115_223 VDD VDD VSS VSS gf180mcu_fd_sc_mcu7t5v0__fillcap_8
XFILLER_115_212 VDD VDD VSS VSS gf180mcu_fd_sc_mcu7t5v0__fill_2
X_3533_ _4096_/Q _3525_/Z _4097_/Q _3535_/A2 VDD VDD VSS VSS gf180mcu_fd_sc_mcu7t5v0__aoi21_1
XFILLER_115_245 VDD VDD VSS VSS gf180mcu_fd_sc_mcu7t5v0__fill_1
X_3464_ _4080_/Q _3549_/B _3538_/B _3465_/B VDD VDD VSS VSS gf180mcu_fd_sc_mcu7t5v0__oai21_1
X_2415_ _2415_/I _3851_/D VDD VDD VSS VSS gf180mcu_fd_sc_mcu7t5v0__clkinv_1
XFILLER_88_107 VDD VDD VSS VSS gf180mcu_fd_sc_mcu7t5v0__fill_2
X_3395_ _3395_/A1 _3396_/A2 _4063_/D VDD VDD VSS VSS gf180mcu_fd_sc_mcu7t5v0__nor2_1
X_2346_ _3820_/Q _2343_/S _2348_/B VDD VDD VSS VSS gf180mcu_fd_sc_mcu7t5v0__nor2_1
X_2277_ _2339_/A1 _2322_/A1 _2277_/B _2362_/C _2278_/I VDD VDD VSS VSS gf180mcu_fd_sc_mcu7t5v0__aoi211_1
XTAP_TAPCELL_ROW_95_820 VDD VSS gf180mcu_fd_sc_mcu7t5v0__filltie
X_4016_ _4016_/D _4017_/CLK _4016_/Q VDD VDD VSS VSS gf180mcu_fd_sc_mcu7t5v0__dffq_1
XFILLER_16_37 VDD VDD VSS VSS gf180mcu_fd_sc_mcu7t5v0__fillcap_4
XFILLER_12_107 VDD VDD VSS VSS gf180mcu_fd_sc_mcu7t5v0__fill_2
XTAP_TAPCELL_ROW_35_463 VDD VSS gf180mcu_fd_sc_mcu7t5v0__filltie
XFILLER_40_416 VDD VDD VSS VSS gf180mcu_fd_sc_mcu7t5v0__fillcap_8
XFILLER_12_129 VDD VDD VSS VSS gf180mcu_fd_sc_mcu7t5v0__fill_2
XFILLER_20_173 VDD VDD VSS VSS gf180mcu_fd_sc_mcu7t5v0__fill_2
XFILLER_4_317 VDD VDD VSS VSS gf180mcu_fd_sc_mcu7t5v0__fillcap_64
Xclkbuf_0__1529_ _3532_/Z clkbuf_0__1529_/Z VDD VDD VSS VSS gf180mcu_fd_sc_mcu7t5v0__clkbuf_16
XFILLER_121_237 VDD VDD VSS VSS gf180mcu_fd_sc_mcu7t5v0__fill_1
XFILLER_113_50 VDD VDD VSS VSS gf180mcu_fd_sc_mcu7t5v0__fill_1
XTAP_TAPCELL_ROW_58_599 VDD VSS gf180mcu_fd_sc_mcu7t5v0__filltie
XFILLER_73_10 VDD VDD VSS VSS gf180mcu_fd_sc_mcu7t5v0__fillcap_8
XFILLER_73_65 VDD VDD VSS VSS gf180mcu_fd_sc_mcu7t5v0__fillcap_4
XFILLER_31_405 VDD VDD VSS VSS gf180mcu_fd_sc_mcu7t5v0__fillcap_8
XTAP_TAPCELL_ROW_41_499 VDD VSS gf180mcu_fd_sc_mcu7t5v0__filltie
XFILLER_7_199 VDD VDD VSS VSS gf180mcu_fd_sc_mcu7t5v0__fillcap_8
XFILLER_112_215 VDD VDD VSS VSS gf180mcu_fd_sc_mcu7t5v0__fillcap_4
X_2200_ _4085_/Q _2248_/A2 _2202_/A1 VDD VDD VSS VSS gf180mcu_fd_sc_mcu7t5v0__nor2_1
X_3180_ wire91/I wire44/Z wire81/I _3181_/B VDD VDD VSS VSS gf180mcu_fd_sc_mcu7t5v0__oai21_1
XFILLER_66_313 VDD VDD VSS VSS gf180mcu_fd_sc_mcu7t5v0__fill_2
X_2131_ hold214/Z _2155_/A2 _2133_/A1 VDD VDD VSS VSS gf180mcu_fd_sc_mcu7t5v0__nor2_1
X_2062_ _3896_/Q _2768_/A2 VDD VDD VSS VSS gf180mcu_fd_sc_mcu7t5v0__clkinv_1
XTAP_TAPCELL_ROW_49_544 VDD VSS gf180mcu_fd_sc_mcu7t5v0__filltie
X_2964_ _4009_/Q _3224_/A1 _3105_/A1 _3953_/Q _2966_/A3 VDD VDD VSS VSS gf180mcu_fd_sc_mcu7t5v0__aoi22_1
XTAP_TAPCELL_ROW_32_444 VDD VSS gf180mcu_fd_sc_mcu7t5v0__filltie
X_1915_ _4030_/Q _3274_/A1 VDD VDD VSS VSS gf180mcu_fd_sc_mcu7t5v0__clkinv_1
X_2895_ _2884_/C _2881_/Z _2895_/A3 _2897_/C VDD VDD VSS VSS gf180mcu_fd_sc_mcu7t5v0__nor3_1
X_3516_ _4093_/Q _3511_/Z _3523_/A2 VDD VDD VSS VSS gf180mcu_fd_sc_mcu7t5v0__nand2_1
XPHY_EDGE_ROW_4_Right_4 VDD VSS gf180mcu_fd_sc_mcu7t5v0__endcap
X_3447_ _4092_/Q _4091_/Q _3447_/A3 _3450_/A1 VDD VDD VSS VSS gf180mcu_fd_sc_mcu7t5v0__nor3_1
XFILLER_57_302 VDD VDD VSS VSS gf180mcu_fd_sc_mcu7t5v0__fill_1
X_3378_ _4132_/Q _3392_/A1 _4064_/Q _3681_/A1 _3385_/C VDD VDD VSS VSS gf180mcu_fd_sc_mcu7t5v0__oai22_1
XFILLER_111_270 VDD VDD VSS VSS gf180mcu_fd_sc_mcu7t5v0__fill_2
X_2329_ _2362_/C _2329_/A2 _3818_/D VDD VDD VSS VSS gf180mcu_fd_sc_mcu7t5v0__nor2_1
XFILLER_13_416 VDD VDD VSS VSS gf180mcu_fd_sc_mcu7t5v0__fillcap_4
XFILLER_25_298 VDD VDD VSS VSS gf180mcu_fd_sc_mcu7t5v0__fillcap_16
XFILLER_40_279 VDD VDD VSS VSS gf180mcu_fd_sc_mcu7t5v0__fillcap_4
XFILLER_104_2 VDD VDD VSS VSS gf180mcu_fd_sc_mcu7t5v0__fillcap_4
XFILLER_0_342 VDD VDD VSS VSS gf180mcu_fd_sc_mcu7t5v0__fillcap_32
XFILLER_95_419 VDD VDD VSS VSS gf180mcu_fd_sc_mcu7t5v0__fill_1
XFILLER_102_281 VDD VDD VSS VSS gf180mcu_fd_sc_mcu7t5v0__fillcap_8
XFILLER_102_270 VDD VDD VSS VSS gf180mcu_fd_sc_mcu7t5v0__fillcap_4
XFILLER_16_265 VDD VDD VSS VSS gf180mcu_fd_sc_mcu7t5v0__fill_2
XFILLER_16_243 VDD VDD VSS VSS gf180mcu_fd_sc_mcu7t5v0__fill_2
XFILLER_31_257 VDD VDD VSS VSS gf180mcu_fd_sc_mcu7t5v0__fillcap_4
X_2680_ _2686_/A2 _2695_/A1 _2680_/A3 _2680_/Z VDD VDD VSS VSS gf180mcu_fd_sc_mcu7t5v0__and3_1
X_3301_ _4041_/Q _3299_/Z _3303_/A2 VDD VDD VSS VSS gf180mcu_fd_sc_mcu7t5v0__nor2_1
X_3232_ _3232_/A1 _3240_/A2 _3232_/B _4010_/D VDD VDD VSS VSS gf180mcu_fd_sc_mcu7t5v0__aoi21_1
X_3163_ wire91/I _3170_/A2 wire81/I _3164_/B VDD VDD VSS VSS gf180mcu_fd_sc_mcu7t5v0__oai21_1
XFILLER_39_302 VDD VDD VSS VSS gf180mcu_fd_sc_mcu7t5v0__fill_2
XFILLER_66_143 VDD VDD VSS VSS gf180mcu_fd_sc_mcu7t5v0__fill_2
X_2114_ hold167/Z _2243_/A2 _3746_/B _2115_/A2 VDD VDD VSS VSS gf180mcu_fd_sc_mcu7t5v0__oai21_1
X_3094_ _3094_/A1 _3104_/A2 _3094_/B _3945_/D VDD VDD VSS VSS gf180mcu_fd_sc_mcu7t5v0__aoi21_1
XFILLER_66_198 VDD VDD VSS VSS gf180mcu_fd_sc_mcu7t5v0__fillcap_4
X_2045_ _3915_/Q _2651_/A2 VDD VDD VSS VSS gf180mcu_fd_sc_mcu7t5v0__clkinv_1
XFILLER_22_268 VDD VDD VSS VSS gf180mcu_fd_sc_mcu7t5v0__fillcap_4
X_3996_ _3996_/D _4149_/CLK _3996_/Q VDD VDD VSS VSS gf180mcu_fd_sc_mcu7t5v0__dffq_1
XFILLER_10_419 VDD VDD VSS VSS gf180mcu_fd_sc_mcu7t5v0__fillcap_4
X_2947_ _3838_/Q _2947_/A2 _2947_/Z VDD VDD VSS VSS gf180mcu_fd_sc_mcu7t5v0__or2_1
X_2878_ _2929_/A1 _2877_/Z _3910_/D VDD VDD VSS VSS gf180mcu_fd_sc_mcu7t5v0__nor2_1
XFILLER_116_395 VDD VDD VSS VSS gf180mcu_fd_sc_mcu7t5v0__fillcap_16
XFILLER_97_290 VDD VDD VSS VSS gf180mcu_fd_sc_mcu7t5v0__fillcap_4
XTAP_TAPCELL_ROW_68_661 VDD VSS gf180mcu_fd_sc_mcu7t5v0__filltie
XPHY_EDGE_ROW_79_Right_79 VDD VSS gf180mcu_fd_sc_mcu7t5v0__endcap
XFILLER_54_45 VDD VDD VSS VSS gf180mcu_fd_sc_mcu7t5v0__fill_2
XFILLER_72_157 VDD VDD VSS VSS gf180mcu_fd_sc_mcu7t5v0__fillcap_4
XFILLER_13_235 VDD VDD VSS VSS gf180mcu_fd_sc_mcu7t5v0__fillcap_4
XFILLER_13_268 VDD VDD VSS VSS gf180mcu_fd_sc_mcu7t5v0__fillcap_4
XTAP_TAPCELL_ROW_51_561 VDD VSS gf180mcu_fd_sc_mcu7t5v0__filltie
XFILLER_70_55 VDD VDD VSS VSS gf180mcu_fd_sc_mcu7t5v0__fill_1
XPHY_EDGE_ROW_88_Right_88 VDD VSS gf180mcu_fd_sc_mcu7t5v0__endcap
XFILLER_79_20 VDD VDD VSS VSS gf180mcu_fd_sc_mcu7t5v0__fill_1
XFILLER_0_172 VDD VDD VSS VSS gf180mcu_fd_sc_mcu7t5v0__fillcap_32
XFILLER_95_238 VDD VDD VSS VSS gf180mcu_fd_sc_mcu7t5v0__fillcap_16
XFILLER_95_74 VDD VDD VSS VSS gf180mcu_fd_sc_mcu7t5v0__fill_1
XPHY_EDGE_ROW_97_Right_97 VDD VSS gf180mcu_fd_sc_mcu7t5v0__endcap
XFILLER_91_422 VDD VDD VSS VSS gf180mcu_fd_sc_mcu7t5v0__fillcap_4
XTAP_TAPCELL_ROW_74_697 VDD VSS gf180mcu_fd_sc_mcu7t5v0__filltie
X_3850_ _3850_/D clkload7/I wire91/I VDD VDD VSS VSS gf180mcu_fd_sc_mcu7t5v0__dffq_1
X_2801_ _2764_/B _2799_/Z _2806_/A1 VDD VDD VSS VSS gf180mcu_fd_sc_mcu7t5v0__nand2_1
X_3781_ _3781_/D _4058_/CLK _3781_/Q VDD VDD VSS VSS gf180mcu_fd_sc_mcu7t5v0__dffq_1
X_2732_ _2743_/A1 _2737_/A2 _2738_/A1 VDD VDD VSS VSS gf180mcu_fd_sc_mcu7t5v0__nand2_1
X_2663_ _3268_/A1 _3905_/Q _2677_/B VDD VDD VSS VSS gf180mcu_fd_sc_mcu7t5v0__nor2_1
X_2594_ _3988_/Q _2643_/B1 _2594_/B _2597_/A2 VDD VDD VSS VSS gf180mcu_fd_sc_mcu7t5v0__oai21_1
XFILLER_59_419 VDD VDD VSS VSS gf180mcu_fd_sc_mcu7t5v0__fill_1
XFILLER_86_238 VDD VDD VSS VSS gf180mcu_fd_sc_mcu7t5v0__fillcap_4
X_3215_ _3215_/A1 _3217_/A2 _3215_/B _4002_/D VDD VDD VSS VSS gf180mcu_fd_sc_mcu7t5v0__aoi21_1
X_4195_ _4195_/I _4195_/Z VDD VDD VSS VSS gf180mcu_fd_sc_mcu7t5v0__buf_1
X_3146_ wire91/Z _3151_/A2 wire81/Z _3147_/B VDD VDD VSS VSS gf180mcu_fd_sc_mcu7t5v0__oai21_1
X_3077_ _3751_/I1 _3082_/A2 wire81/Z _3078_/B VDD VDD VSS VSS gf180mcu_fd_sc_mcu7t5v0__oai21_1
XFILLER_54_179 VDD VDD VSS VSS gf180mcu_fd_sc_mcu7t5v0__fill_1
X_2028_ _3837_/Q _2947_/A2 VDD VDD VSS VSS gf180mcu_fd_sc_mcu7t5v0__clkinv_1
XTAP_TAPCELL_ROW_65_642 VDD VSS gf180mcu_fd_sc_mcu7t5v0__filltie
XFILLER_35_360 VDD VDD VSS VSS gf180mcu_fd_sc_mcu7t5v0__fill_2
XFILLER_24_37 VDD VDD VSS VSS gf180mcu_fd_sc_mcu7t5v0__fillcap_8
X_3979_ _3979_/D _4017_/CLK _3979_/Q VDD VDD VSS VSS gf180mcu_fd_sc_mcu7t5v0__dffq_1
XFILLER_104_321 VDD VDD VSS VSS gf180mcu_fd_sc_mcu7t5v0__fill_2
XTAP_TAPCELL_ROW_88_778 VDD VSS gf180mcu_fd_sc_mcu7t5v0__filltie
XFILLER_18_327 VDD VDD VSS VSS gf180mcu_fd_sc_mcu7t5v0__fill_1
XFILLER_73_422 VDD VDD VSS VSS gf180mcu_fd_sc_mcu7t5v0__fillcap_4
XFILLER_65_88 VDD VDD VSS VSS gf180mcu_fd_sc_mcu7t5v0__fillcap_4
XFILLER_26_382 VDD VDD VSS VSS gf180mcu_fd_sc_mcu7t5v0__fill_2
XFILLER_81_43 VDD VDD VSS VSS gf180mcu_fd_sc_mcu7t5v0__fillcap_16
XTAP_TAPCELL_ROW_71_678 VDD VSS gf180mcu_fd_sc_mcu7t5v0__filltie
XFILLER_14_81 VDD VDD VSS VSS gf180mcu_fd_sc_mcu7t5v0__fill_1
XFILLER_5_286 VDD VDD VSS VSS gf180mcu_fd_sc_mcu7t5v0__fillcap_64
XFILLER_110_313 VDD VDD VSS VSS gf180mcu_fd_sc_mcu7t5v0__fill_2
X_3000_ _2345_/C _3000_/A2 _3922_/D VDD VDD VSS VSS gf180mcu_fd_sc_mcu7t5v0__nor2_1
XFILLER_36_168 VDD VDD VSS VSS gf180mcu_fd_sc_mcu7t5v0__fillcap_4
XTAP_TAPCELL_ROW_19_366 VDD VSS gf180mcu_fd_sc_mcu7t5v0__filltie
XTAP_TAPCELL_ROW_62_623 VDD VSS gf180mcu_fd_sc_mcu7t5v0__filltie
X_3902_ _3902_/D _4034_/CLK _3902_/Q VDD VDD VSS VSS gf180mcu_fd_sc_mcu7t5v0__dffq_1
X_3833_ _3833_/D clkload8/I _3833_/Q VDD VDD VSS VSS gf180mcu_fd_sc_mcu7t5v0__dffq_1
XFILLER_32_374 VDD VDD VSS VSS gf180mcu_fd_sc_mcu7t5v0__fill_1
X_3764_ _3764_/D _4052_/CLK _3764_/Q VDD VDD VSS VSS gf180mcu_fd_sc_mcu7t5v0__dffq_1
X_2715_ _3946_/Q _3888_/Q _2749_/A1 VDD VDD VSS VSS gf180mcu_fd_sc_mcu7t5v0__nor2_1
X_3695_ _3853_/Q _3678_/Z _3696_/B VDD VDD VSS VSS gf180mcu_fd_sc_mcu7t5v0__nand2_1
X_2646_ _2646_/A1 _2646_/A2 _2646_/B _2647_/B VDD VDD VSS VSS gf180mcu_fd_sc_mcu7t5v0__oai21_1
XFILLER_99_330 VDD VDD VSS VSS gf180mcu_fd_sc_mcu7t5v0__fillcap_8
X_2577_ _3979_/Q _2577_/A2 _2577_/B1 _2577_/B2 _2579_/A2 VDD VDD VSS VSS gf180mcu_fd_sc_mcu7t5v0__aoi22_1
XFILLER_99_385 VDD VDD VSS VSS gf180mcu_fd_sc_mcu7t5v0__fill_2
XFILLER_19_26 VDD VDD VSS VSS gf180mcu_fd_sc_mcu7t5v0__fill_2
XFILLER_101_346 VDD VDD VSS VSS gf180mcu_fd_sc_mcu7t5v0__fillcap_4
XFILLER_19_48 VDD VDD VSS VSS gf180mcu_fd_sc_mcu7t5v0__fillcap_8
XFILLER_55_422 VDD VDD VSS VSS gf180mcu_fd_sc_mcu7t5v0__fillcap_4
XFILLER_67_282 VDD VDD VSS VSS gf180mcu_fd_sc_mcu7t5v0__fill_2
XTAP_TAPCELL_ROW_2_267 VDD VSS gf180mcu_fd_sc_mcu7t5v0__filltie
X_3129_ wire91/Z _3138_/A2 wire81/Z _3130_/B VDD VDD VSS VSS gf180mcu_fd_sc_mcu7t5v0__oai21_1
XTAP_TAPCELL_ROW_105_882 VDD VSS gf180mcu_fd_sc_mcu7t5v0__filltie
XFILLER_23_352 VDD VDD VSS VSS gf180mcu_fd_sc_mcu7t5v0__fillcap_64
XFILLER_109_413 VDD VDD VSS VSS gf180mcu_fd_sc_mcu7t5v0__fillcap_4
XFILLER_2_267 VDD VDD VSS VSS gf180mcu_fd_sc_mcu7t5v0__fill_1
XFILLER_92_31 VDD VDD VSS VSS gf180mcu_fd_sc_mcu7t5v0__fillcap_4
XTAP_TAPCELL_ROW_16_347 VDD VSS gf180mcu_fd_sc_mcu7t5v0__filltie
Xclkbuf_1_1__f__1526_ clkbuf_0__1526_/Z _3530_/A2 VDD VDD VSS VSS gf180mcu_fd_sc_mcu7t5v0__clkbuf_16
X_2500_ _2549_/A2 _2555_/A3 _2500_/Z VDD VDD VSS VSS gf180mcu_fd_sc_mcu7t5v0__or2_1
X_3480_ _3552_/C _3480_/A2 _4084_/D VDD VDD VSS VSS gf180mcu_fd_sc_mcu7t5v0__nor2_1
X_2431_ _2461_/A2 _2431_/A2 _2451_/A2 VDD VDD VSS VSS gf180mcu_fd_sc_mcu7t5v0__nand2_1
X_2362_ _2350_/B _2360_/Z _2362_/B _2362_/C _3824_/D VDD VDD VSS VSS gf180mcu_fd_sc_mcu7t5v0__aoi211_1
X_2293_ _2362_/C _2360_/A2 _2363_/A3 VDD VDD VSS VSS gf180mcu_fd_sc_mcu7t5v0__nor2_1
X_4101_ _4101_/D _4104_/CLK _4101_/Q VDD VDD VSS VSS gf180mcu_fd_sc_mcu7t5v0__dffq_1
X_4032_ _4032_/D _4034_/CLK _4032_/Q VDD VDD VSS VSS gf180mcu_fd_sc_mcu7t5v0__dffq_1
XFILLER_37_422 VDD VDD VSS VSS gf180mcu_fd_sc_mcu7t5v0__fillcap_4
XTAP_TAPCELL_ROW_90_795 VDD VSS gf180mcu_fd_sc_mcu7t5v0__filltie
XTAP_TAPCELL_ROW_102_863 VDD VSS gf180mcu_fd_sc_mcu7t5v0__filltie
X_3816_ _3816_/D clkload8/I _3816_/Q VDD VDD VSS VSS gf180mcu_fd_sc_mcu7t5v0__dffq_1
X_3747_ _3747_/A1 _3747_/A2 _4147_/D VDD VDD VSS VSS gf180mcu_fd_sc_mcu7t5v0__nor2_1
XFILLER_118_298 VDD VDD VSS VSS gf180mcu_fd_sc_mcu7t5v0__fillcap_16
X_3678_ _3679_/A1 _3748_/A2 _3678_/Z VDD VDD VSS VSS gf180mcu_fd_sc_mcu7t5v0__and2_1
X_2629_ _3230_/A1 _3887_/Q _3886_/Q _3228_/A1 _2630_/B2 VDD VDD VSS VSS gf180mcu_fd_sc_mcu7t5v0__oai22_1
Xclkbuf_0__1476_ _3462_/ZN clkbuf_0__1476_/Z VDD VDD VSS VSS gf180mcu_fd_sc_mcu7t5v0__clkbuf_16
XFILLER_99_160 VDD VDD VSS VSS gf180mcu_fd_sc_mcu7t5v0__fill_1
XTAP_TAPCELL_ROW_98_840 VDD VSS gf180mcu_fd_sc_mcu7t5v0__filltie
XFILLER_46_13 VDD VDD VSS VSS gf180mcu_fd_sc_mcu7t5v0__fill_2
XFILLER_101_187 VDD VDD VSS VSS gf180mcu_fd_sc_mcu7t5v0__fill_2
Xmax_cap69 _2396_/A2 _2383_/I VDD VDD VSS VSS gf180mcu_fd_sc_mcu7t5v0__clkbuf_2
Xmax_cap58 _3241_/A2 _3275_/A2 VDD VDD VSS VSS gf180mcu_fd_sc_mcu7t5v0__buf_4
Xmax_cap47 _3136_/A2 _3138_/A2 VDD VDD VSS VSS gf180mcu_fd_sc_mcu7t5v0__buf_3
XTAP_TAPCELL_ROW_38_483 VDD VSS gf180mcu_fd_sc_mcu7t5v0__filltie
XTAP_TAPCELL_ROW_81_740 VDD VSS gf180mcu_fd_sc_mcu7t5v0__filltie
XFILLER_23_182 VDD VDD VSS VSS gf180mcu_fd_sc_mcu7t5v0__fillcap_4
XTAP_TAPCELL_ROW_13_328 VDD VSS gf180mcu_fd_sc_mcu7t5v0__filltie
XFILLER_70_288 VDD VDD VSS VSS gf180mcu_fd_sc_mcu7t5v0__fillcap_8
XFILLER_7_18 VDD VDD VSS VSS gf180mcu_fd_sc_mcu7t5v0__fillcap_4
XFILLER_87_31 VDD VDD VSS VSS gf180mcu_fd_sc_mcu7t5v0__fill_2
XFILLER_19_422 VDD VDD VSS VSS gf180mcu_fd_sc_mcu7t5v0__fillcap_4
XFILLER_34_425 VDD VDD VSS VSS gf180mcu_fd_sc_mcu7t5v0__fill_1
XFILLER_61_277 VDD VDD VSS VSS gf180mcu_fd_sc_mcu7t5v0__fill_2
X_2980_ _3987_/Q _3037_/C2 _3044_/A2 _4027_/Q _2984_/A1 VDD VDD VSS VSS gf180mcu_fd_sc_mcu7t5v0__aoi22_1
XFILLER_14_171 VDD VDD VSS VSS gf180mcu_fd_sc_mcu7t5v0__fillcap_4
X_1931_ _4014_/Q _3240_/A1 VDD VDD VSS VSS gf180mcu_fd_sc_mcu7t5v0__clkinv_1
XFILLER_14_193 VDD VDD VSS VSS gf180mcu_fd_sc_mcu7t5v0__fillcap_8
X_3601_ _3674_/B _3720_/A2 _3726_/A1 VDD VDD VSS VSS gf180mcu_fd_sc_mcu7t5v0__nor2_1
X_3532_ _3536_/A2 _3537_/A3 _3532_/Z VDD VDD VSS VSS gf180mcu_fd_sc_mcu7t5v0__and2_1
XFILLER_6_381 VDD VDD VSS VSS gf180mcu_fd_sc_mcu7t5v0__fillcap_4
X_3463_ _3549_/A1 _3463_/A2 _3463_/ZN VDD VDD VSS VSS gf180mcu_fd_sc_mcu7t5v0__nor2_1
XFILLER_115_279 VDD VDD VSS VSS gf180mcu_fd_sc_mcu7t5v0__fill_1
X_2414_ wire90/I wire51/Z _2404_/B _3811_/Q _2415_/I VDD VDD VSS VSS gf180mcu_fd_sc_mcu7t5v0__aoi22_1
XFILLER_103_419 VDD VDD VSS VSS gf180mcu_fd_sc_mcu7t5v0__fill_1
X_3394_ _4063_/Q _3394_/A2 _3396_/A2 VDD VDD VSS VSS gf180mcu_fd_sc_mcu7t5v0__nor2_1
X_2345_ _2345_/A1 _2345_/A2 _2345_/B _2345_/C _3819_/D VDD VDD VSS VSS gf180mcu_fd_sc_mcu7t5v0__aoi211_1
X_2276_ _2292_/A1 _4159_/Q _2333_/B _2277_/B VDD VDD VSS VSS gf180mcu_fd_sc_mcu7t5v0__aoi21_1
XTAP_TAPCELL_ROW_95_821 VDD VSS gf180mcu_fd_sc_mcu7t5v0__filltie
XFILLER_96_174 VDD VDD VSS VSS gf180mcu_fd_sc_mcu7t5v0__fill_1
X_4015_ _4015_/D clkload1/I _4015_/Q VDD VDD VSS VSS gf180mcu_fd_sc_mcu7t5v0__dffq_1
XFILLER_16_27 VDD VDD VSS VSS gf180mcu_fd_sc_mcu7t5v0__fill_2
XFILLER_52_233 VDD VDD VSS VSS gf180mcu_fd_sc_mcu7t5v0__fillcap_8
XTAP_TAPCELL_ROW_35_464 VDD VSS gf180mcu_fd_sc_mcu7t5v0__filltie
XFILLER_120_8 VDD VDD VSS VSS gf180mcu_fd_sc_mcu7t5v0__fill_1
Xclkbuf_1_0__f_ext_clk_in clkbuf_0_ext_clk_in/Z clkbuf_leaf_1_ext_clk_in/I VDD VDD
+ VSS VSS gf180mcu_fd_sc_mcu7t5v0__clkbuf_16
XFILLER_73_22 VDD VDD VSS VSS gf180mcu_fd_sc_mcu7t5v0__fill_1
XFILLER_90_317 VDD VDD VSS VSS gf180mcu_fd_sc_mcu7t5v0__fill_2
XFILLER_16_425 VDD VDD VSS VSS gf180mcu_fd_sc_mcu7t5v0__fill_1
XFILLER_31_417 VDD VDD VSS VSS gf180mcu_fd_sc_mcu7t5v0__fill_2
XFILLER_43_277 VDD VDD VSS VSS gf180mcu_fd_sc_mcu7t5v0__fill_2
XTAP_TAPCELL_ROW_121_980 VDD VSS gf180mcu_fd_sc_mcu7t5v0__filltie
XFILLER_98_74 VDD VDD VSS VSS gf180mcu_fd_sc_mcu7t5v0__fillcap_8
XFILLER_112_238 VDD VDD VSS VSS gf180mcu_fd_sc_mcu7t5v0__fillcap_4
XFILLER_21_6 VDD VDD VSS VSS gf180mcu_fd_sc_mcu7t5v0__fillcap_8
XFILLER_78_185 VDD VDD VSS VSS gf180mcu_fd_sc_mcu7t5v0__fillcap_16
X_2130_ _2130_/A1 _2130_/A2 hold162/I VDD VDD VSS VSS gf180mcu_fd_sc_mcu7t5v0__nor2_1
XFILLER_19_241 VDD VDD VSS VSS gf180mcu_fd_sc_mcu7t5v0__fillcap_8
X_2061_ _3897_/Q _2784_/A2 VDD VDD VSS VSS gf180mcu_fd_sc_mcu7t5v0__clkinv_1
XTAP_TAPCELL_ROW_49_545 VDD VSS gf180mcu_fd_sc_mcu7t5v0__filltie
XFILLER_93_155 VDD VDD VSS VSS gf180mcu_fd_sc_mcu7t5v0__fill_1
XFILLER_19_263 VDD VDD VSS VSS gf180mcu_fd_sc_mcu7t5v0__fill_2
XTAP_TAPCELL_ROW_92_802 VDD VSS gf180mcu_fd_sc_mcu7t5v0__filltie
XFILLER_97_2 VDD VDD VSS VSS gf180mcu_fd_sc_mcu7t5v0__fill_2
X_2963_ _3969_/Q _3139_/A1 _3057_/A1 _3937_/Q _2966_/A2 VDD VDD VSS VSS gf180mcu_fd_sc_mcu7t5v0__aoi22_1
XTAP_TAPCELL_ROW_32_445 VDD VSS gf180mcu_fd_sc_mcu7t5v0__filltie
X_1914_ _4031_/Q _3277_/A1 VDD VDD VSS VSS gf180mcu_fd_sc_mcu7t5v0__clkinv_1
X_2894_ _2894_/A1 _2895_/A3 _2897_/A2 VDD VDD VSS VSS gf180mcu_fd_sc_mcu7t5v0__nor2_1
X_3515_ _3515_/A1 _3515_/A2 _4092_/D VDD VDD VSS VSS gf180mcu_fd_sc_mcu7t5v0__nor2_1
X_3446_ _3446_/A1 _3446_/A2 _3446_/B _3447_/A3 VDD VDD VSS VSS gf180mcu_fd_sc_mcu7t5v0__aoi21_1
X_3377_ _4130_/Q _3377_/A2 _4067_/Q _3688_/A1 _3387_/A2 VDD VDD VSS VSS gf180mcu_fd_sc_mcu7t5v0__aoi22_1
XFILLER_111_282 VDD VDD VSS VSS gf180mcu_fd_sc_mcu7t5v0__fill_1
X_2328_ _3817_/Q _2328_/A2 _3818_/Q _2329_/A2 VDD VDD VSS VSS gf180mcu_fd_sc_mcu7t5v0__aoi21_1
XFILLER_57_358 VDD VDD VSS VSS gf180mcu_fd_sc_mcu7t5v0__fill_1
X_2259_ _3833_/Q _3834_/Q _2319_/A2 _2259_/B2 _4159_/Q _2290_/A1 VDD VDD VSS VSS gf180mcu_fd_sc_mcu7t5v0__oai221_1
XFILLER_72_317 VDD VDD VSS VSS gf180mcu_fd_sc_mcu7t5v0__fillcap_8
XFILLER_40_247 VDD VDD VSS VSS gf180mcu_fd_sc_mcu7t5v0__fillcap_32
XFILLER_43_69 VDD VDD VSS VSS gf180mcu_fd_sc_mcu7t5v0__fill_1
XFILLER_108_51 VDD VDD VSS VSS gf180mcu_fd_sc_mcu7t5v0__fillcap_8
XFILLER_68_66 VDD VDD VSS VSS gf180mcu_fd_sc_mcu7t5v0__fillcap_8
XFILLER_0_376 VDD VDD VSS VSS gf180mcu_fd_sc_mcu7t5v0__fillcap_32
XFILLER_75_166 VDD VDD VSS VSS gf180mcu_fd_sc_mcu7t5v0__fill_1
XTAP_TAPCELL_ROW_46_526 VDD VSS gf180mcu_fd_sc_mcu7t5v0__filltie
XFILLER_17_81 VDD VDD VSS VSS gf180mcu_fd_sc_mcu7t5v0__fillcap_4
XFILLER_31_214 VDD VDD VSS VSS gf180mcu_fd_sc_mcu7t5v0__fill_1
XFILLER_69_6 VDD VDD VSS VSS gf180mcu_fd_sc_mcu7t5v0__fill_1
X_3300_ _3363_/B _3300_/A2 _3299_/Z _4040_/D VDD VDD VSS VSS gf180mcu_fd_sc_mcu7t5v0__nor3_1
XFILLER_3_181 VDD VDD VSS VSS gf180mcu_fd_sc_mcu7t5v0__fillcap_4
XFILLER_98_247 VDD VDD VSS VSS gf180mcu_fd_sc_mcu7t5v0__fillcap_4
X_3231_ wire91/I _3240_/A2 wire81/I _3232_/B VDD VDD VSS VSS gf180mcu_fd_sc_mcu7t5v0__oai21_1
XFILLER_98_258 VDD VDD VSS VSS gf180mcu_fd_sc_mcu7t5v0__fillcap_4
X_3162_ _3162_/A1 _3170_/A2 _3162_/B _3977_/D VDD VDD VSS VSS gf180mcu_fd_sc_mcu7t5v0__aoi21_1
XFILLER_12_2 VDD VDD VSS VSS gf180mcu_fd_sc_mcu7t5v0__fill_1
X_2113_ _4039_/Q _2155_/A2 _2115_/A1 VDD VDD VSS VSS gf180mcu_fd_sc_mcu7t5v0__nor2_1
X_3093_ _3849_/Q _3104_/A2 wire81/I _3094_/B VDD VDD VSS VSS gf180mcu_fd_sc_mcu7t5v0__oai21_1
X_2044_ _3916_/Q _2915_/A2 VDD VDD VSS VSS gf180mcu_fd_sc_mcu7t5v0__clkinv_1
XFILLER_81_136 VDD VDD VSS VSS gf180mcu_fd_sc_mcu7t5v0__fillcap_4
XFILLER_22_225 VDD VDD VSS VSS gf180mcu_fd_sc_mcu7t5v0__fillcap_4
X_3995_ _3995_/D _4149_/CLK _3995_/Q VDD VDD VSS VSS gf180mcu_fd_sc_mcu7t5v0__dffq_1
X_2946_ _3840_/Q _3839_/Q wire79/Z _2958_/A2 VDD VDD VSS VSS gf180mcu_fd_sc_mcu7t5v0__nand3_1
X_2877_ _2877_/A1 _2877_/A2 _2877_/Z VDD VDD VSS VSS gf180mcu_fd_sc_mcu7t5v0__xor2_1
XPHY_EDGE_ROW_111_Right_111 VDD VSS gf180mcu_fd_sc_mcu7t5v0__endcap
XFILLER_1_118 VDD VDD VSS VSS gf180mcu_fd_sc_mcu7t5v0__fill_1
XFILLER_1_129 VDD VDD VSS VSS gf180mcu_fd_sc_mcu7t5v0__fill_2
X_3429_ _3401_/I _3429_/A2 _3428_/Z _4075_/D VDD VDD VSS VSS gf180mcu_fd_sc_mcu7t5v0__nor3_1
XFILLER_38_14 VDD VDD VSS VSS gf180mcu_fd_sc_mcu7t5v0__fillcap_8
XFILLER_57_133 VDD VDD VSS VSS gf180mcu_fd_sc_mcu7t5v0__fillcap_4
XFILLER_57_155 VDD VDD VSS VSS gf180mcu_fd_sc_mcu7t5v0__fill_1
XTAP_TAPCELL_ROW_68_662 VDD VSS gf180mcu_fd_sc_mcu7t5v0__filltie
XFILLER_13_203 VDD VDD VSS VSS gf180mcu_fd_sc_mcu7t5v0__fillcap_4
XFILLER_79_65 VDD VDD VSS VSS gf180mcu_fd_sc_mcu7t5v0__fill_1
XPHY_EDGE_ROW_79_Left_201 VDD VSS gf180mcu_fd_sc_mcu7t5v0__endcap
XFILLER_95_228 VDD VDD VSS VSS gf180mcu_fd_sc_mcu7t5v0__fill_2
XFILLER_88_280 VDD VDD VSS VSS gf180mcu_fd_sc_mcu7t5v0__fill_2
XFILLER_36_317 VDD VDD VSS VSS gf180mcu_fd_sc_mcu7t5v0__fill_2
XFILLER_63_169 VDD VDD VSS VSS gf180mcu_fd_sc_mcu7t5v0__fillcap_8
XPHY_EDGE_ROW_88_Left_210 VDD VSS gf180mcu_fd_sc_mcu7t5v0__endcap
XTAP_TAPCELL_ROW_74_698 VDD VSS gf180mcu_fd_sc_mcu7t5v0__filltie
X_2800_ _2757_/Z _2799_/Z _2800_/Z VDD VDD VSS VSS gf180mcu_fd_sc_mcu7t5v0__and2_1
X_3780_ _3780_/D _4058_/CLK _3780_/Q VDD VDD VSS VSS gf180mcu_fd_sc_mcu7t5v0__dffq_1
X_2731_ _3102_/A1 _2746_/A2 _2737_/A2 VDD VDD VSS VSS gf180mcu_fd_sc_mcu7t5v0__nand2_1
XFILLER_74_4 VDD VDD VSS VSS gf180mcu_fd_sc_mcu7t5v0__fill_1
X_2662_ _4027_/Q _2844_/A2 _2687_/A2 _4026_/Q _2678_/B VDD VDD VSS VSS gf180mcu_fd_sc_mcu7t5v0__oai22_1
X_2593_ _3183_/A1 _3897_/Q _2593_/B _2594_/B VDD VDD VSS VSS gf180mcu_fd_sc_mcu7t5v0__oai21_1
XFILLER_113_377 VDD VDD VSS VSS gf180mcu_fd_sc_mcu7t5v0__fill_1
X_3214_ wire91/Z _3217_/A2 wire81/Z _3215_/B VDD VDD VSS VSS gf180mcu_fd_sc_mcu7t5v0__oai21_1
X_3145_ _3145_/A1 _3151_/A2 _3145_/B _3969_/D VDD VDD VSS VSS gf180mcu_fd_sc_mcu7t5v0__aoi21_1
X_3076_ _3076_/A1 _3080_/A2 _3076_/B _3937_/D VDD VDD VSS VSS gf180mcu_fd_sc_mcu7t5v0__aoi21_1
XFILLER_54_103 VDD VDD VSS VSS gf180mcu_fd_sc_mcu7t5v0__fill_2
X_2027_ _3839_/Q _2930_/A2 VDD VDD VSS VSS gf180mcu_fd_sc_mcu7t5v0__clkinv_1
XTAP_TAPCELL_ROW_65_643 VDD VSS gf180mcu_fd_sc_mcu7t5v0__filltie
X_3978_ _3978_/D _4017_/CLK _3978_/Q VDD VDD VSS VSS gf180mcu_fd_sc_mcu7t5v0__dffq_1
X_2929_ _2929_/A1 _2929_/A2 _3918_/D VDD VDD VSS VSS gf180mcu_fd_sc_mcu7t5v0__nor2_1
XFILLER_49_35 VDD VDD VSS VSS gf180mcu_fd_sc_mcu7t5v0__fillcap_4
XFILLER_49_57 VDD VDD VSS VSS gf180mcu_fd_sc_mcu7t5v0__fillcap_4
XFILLER_18_317 VDD VDD VSS VSS gf180mcu_fd_sc_mcu7t5v0__fill_2
XTAP_TAPCELL_ROW_88_779 VDD VSS gf180mcu_fd_sc_mcu7t5v0__filltie
XFILLER_45_114 VDD VDD VSS VSS gf180mcu_fd_sc_mcu7t5v0__fill_2
XFILLER_121_84 VDD VDD VSS VSS gf180mcu_fd_sc_mcu7t5v0__fill_1
Xclkbuf_1_1__f__1473_ clkbuf_0__1473_/Z clkbuf_leaf_5__1473_/I VDD VDD VSS VSS gf180mcu_fd_sc_mcu7t5v0__clkbuf_16
XTAP_TAPCELL_ROW_71_679 VDD VSS gf180mcu_fd_sc_mcu7t5v0__filltie
XFILLER_14_71 VDD VDD VSS VSS gf180mcu_fd_sc_mcu7t5v0__fillcap_8
XFILLER_5_265 VDD VDD VSS VSS gf180mcu_fd_sc_mcu7t5v0__fill_1
XTAP_TAPCELL_ROW_79_724 VDD VSS gf180mcu_fd_sc_mcu7t5v0__filltie
XTAP_TAPCELL_ROW_19_367 VDD VSS gf180mcu_fd_sc_mcu7t5v0__filltie
XFILLER_51_128 VDD VDD VSS VSS gf180mcu_fd_sc_mcu7t5v0__fillcap_4
XTAP_TAPCELL_ROW_62_624 VDD VSS gf180mcu_fd_sc_mcu7t5v0__filltie
XFILLER_91_297 VDD VDD VSS VSS gf180mcu_fd_sc_mcu7t5v0__fillcap_16
X_3901_ _3901_/D _4034_/CLK _3901_/Q VDD VDD VSS VSS gf180mcu_fd_sc_mcu7t5v0__dffq_1
X_3832_ _3832_/D clkload6/I _3832_/Q VDD VDD VSS VSS gf180mcu_fd_sc_mcu7t5v0__dffq_1
X_3763_ _3763_/D _4058_/CLK _3763_/Q VDD VDD VSS VSS gf180mcu_fd_sc_mcu7t5v0__dffq_1
XFILLER_118_425 VDD VDD VSS VSS gf180mcu_fd_sc_mcu7t5v0__fill_1
X_2714_ _3094_/A1 _2714_/A2 _2714_/B _2716_/A3 VDD VDD VSS VSS gf180mcu_fd_sc_mcu7t5v0__oai21_1
X_3694_ _3746_/B _3694_/A2 _3694_/A3 _4129_/D VDD VDD VSS VSS gf180mcu_fd_sc_mcu7t5v0__nand3_1
X_2645_ _2645_/A1 _2646_/A1 _2646_/B _2645_/A4 _2648_/A2 VDD VDD VSS VSS gf180mcu_fd_sc_mcu7t5v0__nand4_1
X_2576_ _3166_/A1 _3889_/Q _3888_/Q _3164_/A1 _2577_/B2 VDD VDD VSS VSS gf180mcu_fd_sc_mcu7t5v0__aoi22_1
XFILLER_99_342 VDD VDD VSS VSS gf180mcu_fd_sc_mcu7t5v0__fill_2
XFILLER_101_358 VDD VDD VSS VSS gf180mcu_fd_sc_mcu7t5v0__fill_1
X_3128_ _3128_/A1 _3138_/A2 _3128_/B _3961_/D VDD VDD VSS VSS gf180mcu_fd_sc_mcu7t5v0__aoi21_1
XFILLER_82_242 VDD VDD VSS VSS gf180mcu_fd_sc_mcu7t5v0__fill_2
X_3059_ _3059_/A1 _3080_/A2 _3059_/B _3929_/D VDD VDD VSS VSS gf180mcu_fd_sc_mcu7t5v0__aoi21_1
XFILLER_42_139 VDD VDD VSS VSS gf180mcu_fd_sc_mcu7t5v0__fill_1
XTAP_TAPCELL_ROW_105_883 VDD VSS gf180mcu_fd_sc_mcu7t5v0__filltie
XFILLER_51_69 VDD VDD VSS VSS gf180mcu_fd_sc_mcu7t5v0__fill_1
XFILLER_2_257 VDD VDD VSS VSS gf180mcu_fd_sc_mcu7t5v0__fillcap_8
XFILLER_104_174 VDD VDD VSS VSS gf180mcu_fd_sc_mcu7t5v0__fill_1
XFILLER_65_209 VDD VDD VSS VSS gf180mcu_fd_sc_mcu7t5v0__fill_1
XFILLER_100_380 VDD VDD VSS VSS gf180mcu_fd_sc_mcu7t5v0__fillcap_4
XTAP_TAPCELL_ROW_16_348 VDD VSS gf180mcu_fd_sc_mcu7t5v0__filltie
XFILLER_33_139 VDD VDD VSS VSS gf180mcu_fd_sc_mcu7t5v0__fill_1
X_2430_ _2461_/A2 _2431_/A2 _2430_/Z VDD VDD VSS VSS gf180mcu_fd_sc_mcu7t5v0__and2_1
X_2361_ _3824_/Q _2361_/A2 _2362_/B VDD VDD VSS VSS gf180mcu_fd_sc_mcu7t5v0__nor2_1
X_2292_ _2292_/A1 _4158_/Q _2360_/A2 VDD VDD VSS VSS gf180mcu_fd_sc_mcu7t5v0__nand2_1
X_4100_ _4100_/D _4142_/CLK _4100_/Q VDD VDD VSS VSS gf180mcu_fd_sc_mcu7t5v0__dffq_1
XFILLER_96_323 VDD VDD VSS VSS gf180mcu_fd_sc_mcu7t5v0__fill_1
XPHY_EDGE_ROW_16_Left_138 VDD VSS gf180mcu_fd_sc_mcu7t5v0__endcap
X_4031_ _4031_/D _4034_/CLK _4031_/Q VDD VDD VSS VSS gf180mcu_fd_sc_mcu7t5v0__dffq_1
XTAP_TAPCELL_ROW_119_964 VDD VSS gf180mcu_fd_sc_mcu7t5v0__filltie
XTAP_TAPCELL_ROW_102_864 VDD VSS gf180mcu_fd_sc_mcu7t5v0__filltie
XPHY_EDGE_ROW_25_Left_147 VDD VSS gf180mcu_fd_sc_mcu7t5v0__endcap
X_3815_ _3815_/D clkload8/I _3815_/Q VDD VDD VSS VSS gf180mcu_fd_sc_mcu7t5v0__dffq_1
X_3746_ _3754_/I1 _3746_/A2 _3746_/B _3747_/A2 VDD VDD VSS VSS gf180mcu_fd_sc_mcu7t5v0__oai21_1
X_3677_ _3677_/A1 _3677_/A2 _4123_/D VDD VDD VSS VSS gf180mcu_fd_sc_mcu7t5v0__nand2_1
X_2628_ _3228_/A1 _3886_/Q _3885_/Q _2628_/C _2630_/B1 VDD VDD VSS VSS gf180mcu_fd_sc_mcu7t5v0__aoi211_1
X_2559_ _3196_/A1 _3903_/Q _3902_/Q _3194_/A1 _2601_/A1 VDD VDD VSS VSS gf180mcu_fd_sc_mcu7t5v0__oai22_1
XPHY_EDGE_ROW_34_Left_156 VDD VSS gf180mcu_fd_sc_mcu7t5v0__endcap
XTAP_TAPCELL_ROW_98_841 VDD VSS gf180mcu_fd_sc_mcu7t5v0__filltie
XFILLER_99_183 VDD VDD VSS VSS gf180mcu_fd_sc_mcu7t5v0__fill_1
XFILLER_101_144 VDD VDD VSS VSS gf180mcu_fd_sc_mcu7t5v0__fill_1
XFILLER_55_220 VDD VDD VSS VSS gf180mcu_fd_sc_mcu7t5v0__fill_1
Xmax_cap48 _3108_/A2 _3121_/A2 VDD VDD VSS VSS gf180mcu_fd_sc_mcu7t5v0__buf_3
Xmax_cap59 _3042_/B1 _3105_/A1 VDD VDD VSS VSS gf180mcu_fd_sc_mcu7t5v0__buf_2
XFILLER_15_139 VDD VDD VSS VSS gf180mcu_fd_sc_mcu7t5v0__fill_1
XTAP_TAPCELL_ROW_81_741 VDD VSS gf180mcu_fd_sc_mcu7t5v0__filltie
XFILLER_102_31 VDD VDD VSS VSS gf180mcu_fd_sc_mcu7t5v0__fillcap_4
XPHY_EDGE_ROW_43_Left_165 VDD VSS gf180mcu_fd_sc_mcu7t5v0__endcap
XFILLER_62_46 VDD VDD VSS VSS gf180mcu_fd_sc_mcu7t5v0__fillcap_4
XTAP_TAPCELL_ROW_13_329 VDD VSS gf180mcu_fd_sc_mcu7t5v0__filltie
XFILLER_11_323 VDD VDD VSS VSS gf180mcu_fd_sc_mcu7t5v0__fill_1
XFILLER_11_72 VDD VDD VSS VSS gf180mcu_fd_sc_mcu7t5v0__fill_2
XPHY_EDGE_ROW_52_Left_174 VDD VSS gf180mcu_fd_sc_mcu7t5v0__endcap
XFILLER_78_378 VDD VDD VSS VSS gf180mcu_fd_sc_mcu7t5v0__fillcap_4
XPHY_EDGE_ROW_61_Left_183 VDD VSS gf180mcu_fd_sc_mcu7t5v0__endcap
XFILLER_61_212 VDD VDD VSS VSS gf180mcu_fd_sc_mcu7t5v0__fill_1
XFILLER_61_267 VDD VDD VSS VSS gf180mcu_fd_sc_mcu7t5v0__fill_2
X_1930_ _4015_/Q _3243_/A1 VDD VDD VSS VSS gf180mcu_fd_sc_mcu7t5v0__clkinv_1
X_3600_ _3674_/B _2947_/Z _3638_/A2 VDD VDD VSS VSS gf180mcu_fd_sc_mcu7t5v0__nor2_1
X_3531_ _4097_/Q _4096_/Q _3525_/Z _3537_/A3 VDD VDD VSS VSS gf180mcu_fd_sc_mcu7t5v0__nand3_1
XFILLER_115_214 VDD VDD VSS VSS gf180mcu_fd_sc_mcu7t5v0__fill_1
X_3462_ _3462_/A1 _3461_/Z _3462_/ZN VDD VDD VSS VSS gf180mcu_fd_sc_mcu7t5v0__nand2_1
XPHY_EDGE_ROW_70_Left_192 VDD VSS gf180mcu_fd_sc_mcu7t5v0__endcap
X_2413_ _2413_/I _3850_/D VDD VDD VSS VSS gf180mcu_fd_sc_mcu7t5v0__clkinv_1
XFILLER_69_301 VDD VDD VSS VSS gf180mcu_fd_sc_mcu7t5v0__fill_2
X_3393_ _3393_/A1 _3392_/Z _3393_/B _3394_/A2 VDD VDD VSS VSS gf180mcu_fd_sc_mcu7t5v0__aoi21_1
X_2344_ _2344_/I _2345_/A2 VDD VDD VSS VSS gf180mcu_fd_sc_mcu7t5v0__clkinv_1
X_2275_ _3833_/Q _2363_/A2 _2322_/A1 VDD VDD VSS VSS gf180mcu_fd_sc_mcu7t5v0__nor2_1
XTAP_TAPCELL_ROW_95_822 VDD VSS gf180mcu_fd_sc_mcu7t5v0__filltie
X_4014_ _4014_/D clkload1/I _4014_/Q VDD VDD VSS VSS gf180mcu_fd_sc_mcu7t5v0__dffq_1
XFILLER_12_109 VDD VDD VSS VSS gf180mcu_fd_sc_mcu7t5v0__fill_1
XTAP_TAPCELL_ROW_35_465 VDD VSS gf180mcu_fd_sc_mcu7t5v0__filltie
XFILLER_20_153 VDD VDD VSS VSS gf180mcu_fd_sc_mcu7t5v0__fillcap_16
XFILLER_4_308 VDD VDD VSS VSS gf180mcu_fd_sc_mcu7t5v0__fillcap_4
X_3729_ _2092_/I _3729_/A2 _3729_/B _3730_/I VDD VDD VSS VSS gf180mcu_fd_sc_mcu7t5v0__aoi21_1
XFILLER_106_225 VDD VDD VSS VSS gf180mcu_fd_sc_mcu7t5v0__fillcap_8
XFILLER_106_247 VDD VDD VSS VSS gf180mcu_fd_sc_mcu7t5v0__fillcap_8
XFILLER_121_206 VDD VDD VSS VSS gf180mcu_fd_sc_mcu7t5v0__fillcap_4
XFILLER_87_142 VDD VDD VSS VSS gf180mcu_fd_sc_mcu7t5v0__fillcap_4
XFILLER_57_57 VDD VDD VSS VSS gf180mcu_fd_sc_mcu7t5v0__fillcap_4
XFILLER_113_85 VDD VDD VSS VSS gf180mcu_fd_sc_mcu7t5v0__fillcap_8
XTAP_TAPCELL_ROW_26_410 VDD VSS gf180mcu_fd_sc_mcu7t5v0__filltie
XFILLER_43_212 VDD VDD VSS VSS gf180mcu_fd_sc_mcu7t5v0__fill_1
XFILLER_83_381 VDD VDD VSS VSS gf180mcu_fd_sc_mcu7t5v0__fillcap_4
Xwire90 wire90/I wire90/Z VDD VDD VSS VSS gf180mcu_fd_sc_mcu7t5v0__buf_4
XTAP_TAPCELL_ROW_121_981 VDD VSS gf180mcu_fd_sc_mcu7t5v0__filltie
XFILLER_7_124 VDD VDD VSS VSS gf180mcu_fd_sc_mcu7t5v0__fill_2
XFILLER_7_135 VDD VDD VSS VSS gf180mcu_fd_sc_mcu7t5v0__fillcap_4
XFILLER_7_146 VDD VDD VSS VSS gf180mcu_fd_sc_mcu7t5v0__fill_1
XFILLER_7_157 VDD VDD VSS VSS gf180mcu_fd_sc_mcu7t5v0__fill_2
XFILLER_7_179 VDD VDD VSS VSS gf180mcu_fd_sc_mcu7t5v0__fill_2
XFILLER_98_31 VDD VDD VSS VSS gf180mcu_fd_sc_mcu7t5v0__fillcap_4
XFILLER_3_352 VDD VDD VSS VSS gf180mcu_fd_sc_mcu7t5v0__fillcap_64
XFILLER_98_64 VDD VDD VSS VSS gf180mcu_fd_sc_mcu7t5v0__fill_2
XFILLER_78_164 VDD VDD VSS VSS gf180mcu_fd_sc_mcu7t5v0__fill_2
X_2060_ _3898_/Q _2643_/B1 VDD VDD VSS VSS gf180mcu_fd_sc_mcu7t5v0__clkinv_1
XTAP_TAPCELL_ROW_49_546 VDD VSS gf180mcu_fd_sc_mcu7t5v0__filltie
XFILLER_19_253 VDD VDD VSS VSS gf180mcu_fd_sc_mcu7t5v0__fill_2
XTAP_TAPCELL_ROW_92_803 VDD VSS gf180mcu_fd_sc_mcu7t5v0__filltie
XFILLER_34_256 VDD VDD VSS VSS gf180mcu_fd_sc_mcu7t5v0__fillcap_16
XFILLER_34_278 VDD VDD VSS VSS gf180mcu_fd_sc_mcu7t5v0__fillcap_4
X_2962_ _3985_/Q _3037_/C2 _3027_/C1 _4033_/Q _2962_/C _2966_/A1 VDD VDD VSS VSS gf180mcu_fd_sc_mcu7t5v0__aoi221_1
XTAP_TAPCELL_ROW_32_446 VDD VSS gf180mcu_fd_sc_mcu7t5v0__filltie
X_1913_ _4032_/Q _3279_/A1 VDD VDD VSS VSS gf180mcu_fd_sc_mcu7t5v0__clkinv_1
X_2893_ _2885_/B _2897_/B2 _2896_/B _2895_/A3 VDD VDD VSS VSS gf180mcu_fd_sc_mcu7t5v0__nand3_1
XTAP_TAPCELL_ROW_40_490 VDD VSS gf180mcu_fd_sc_mcu7t5v0__filltie
X_3514_ _4092_/Q _3508_/I _3538_/B _3515_/A2 VDD VDD VSS VSS gf180mcu_fd_sc_mcu7t5v0__oai21_1
X_3445_ _4090_/Q _4089_/Q _3446_/B VDD VDD VSS VSS gf180mcu_fd_sc_mcu7t5v0__nand2_1
XFILLER_89_418 VDD VDD VSS VSS gf180mcu_fd_sc_mcu7t5v0__fill_2
XFILLER_69_142 VDD VDD VSS VSS gf180mcu_fd_sc_mcu7t5v0__fill_1
X_3376_ _4128_/Q _4068_/Q _3376_/Z VDD VDD VSS VSS gf180mcu_fd_sc_mcu7t5v0__xor2_1
X_2327_ _2362_/C _2327_/A2 _3817_/D VDD VDD VSS VSS gf180mcu_fd_sc_mcu7t5v0__nor2_1
X_2258_ _3824_/Q _4158_/Q _2333_/B _2258_/B _2259_/B2 VDD VDD VSS VSS gf180mcu_fd_sc_mcu7t5v0__oai31_1
XPHY_EDGE_ROW_108_Left_230 VDD VSS gf180mcu_fd_sc_mcu7t5v0__endcap
X_2189_ _3783_/Q _2243_/A2 _3746_/B _2190_/A2 VDD VDD VSS VSS gf180mcu_fd_sc_mcu7t5v0__oai21_1
XFILLER_84_189 VDD VDD VSS VSS gf180mcu_fd_sc_mcu7t5v0__fill_1
XFILLER_25_278 VDD VDD VSS VSS gf180mcu_fd_sc_mcu7t5v0__fill_2
XFILLER_43_59 VDD VDD VSS VSS gf180mcu_fd_sc_mcu7t5v0__fillcap_8
XTAP_TAPCELL_ROW_46_527 VDD VSS gf180mcu_fd_sc_mcu7t5v0__filltie
XFILLER_16_267 VDD VDD VSS VSS gf180mcu_fd_sc_mcu7t5v0__fill_1
X_3230_ _3230_/A1 _3240_/A2 _3230_/B _4009_/D VDD VDD VSS VSS gf180mcu_fd_sc_mcu7t5v0__aoi21_1
X_3161_ _3849_/Q _3170_/A2 wire81/I _3162_/B VDD VDD VSS VSS gf180mcu_fd_sc_mcu7t5v0__oai21_1
XFILLER_66_145 VDD VDD VSS VSS gf180mcu_fd_sc_mcu7t5v0__fill_1
X_2112_ _2112_/A1 _3721_/A1 _2248_/A2 VDD VDD VSS VSS gf180mcu_fd_sc_mcu7t5v0__nand2_1
XFILLER_94_421 VDD VDD VSS VSS gf180mcu_fd_sc_mcu7t5v0__fillcap_4
X_3092_ _3092_/A1 _3104_/A2 _3092_/B _3944_/D VDD VDD VSS VSS gf180mcu_fd_sc_mcu7t5v0__aoi21_1
X_2043_ _3816_/Q _2459_/A1 VDD VDD VSS VSS gf180mcu_fd_sc_mcu7t5v0__clkinv_1
X_3994_ _3994_/D _4149_/CLK _3994_/Q VDD VDD VSS VSS gf180mcu_fd_sc_mcu7t5v0__dffq_1
X_2945_ _3720_/A2 _2957_/A1 _3241_/A1 VDD VDD VSS VSS gf180mcu_fd_sc_mcu7t5v0__nor2_1
X_2876_ _2881_/A1 _2884_/A1 _2877_/A2 VDD VDD VSS VSS gf180mcu_fd_sc_mcu7t5v0__nand2_1
X_3428_ _4075_/Q _4074_/Q _3423_/Z _3428_/Z VDD VDD VSS VSS gf180mcu_fd_sc_mcu7t5v0__and3_1
XFILLER_38_26 VDD VDD VSS VSS gf180mcu_fd_sc_mcu7t5v0__fill_1
X_3359_ _4059_/Q _3354_/Z _4060_/Q _3361_/A2 VDD VDD VSS VSS gf180mcu_fd_sc_mcu7t5v0__aoi21_1
XFILLER_38_37 VDD VDD VSS VSS gf180mcu_fd_sc_mcu7t5v0__fill_1
XTAP_TAPCELL_ROW_68_663 VDD VSS gf180mcu_fd_sc_mcu7t5v0__filltie
XFILLER_72_137 VDD VDD VSS VSS gf180mcu_fd_sc_mcu7t5v0__fillcap_4
XTAP_TAPCELL_ROW_43_508 VDD VSS gf180mcu_fd_sc_mcu7t5v0__filltie
XFILLER_9_208 VDD VDD VSS VSS gf180mcu_fd_sc_mcu7t5v0__fill_2
Xclkbuf_leaf_19_ext_clk_in clkbuf_leaf_1_ext_clk_in/I clkload8/I VDD VDD VSS VSS gf180mcu_fd_sc_mcu7t5v0__clkbuf_8
XFILLER_107_320 VDD VDD VSS VSS gf180mcu_fd_sc_mcu7t5v0__fillcap_4
XFILLER_79_88 VDD VDD VSS VSS gf180mcu_fd_sc_mcu7t5v0__fillcap_8
XFILLER_95_207 VDD VDD VSS VSS gf180mcu_fd_sc_mcu7t5v0__fill_2
XFILLER_48_156 VDD VDD VSS VSS gf180mcu_fd_sc_mcu7t5v0__fillcap_8
XFILLER_29_370 VDD VDD VSS VSS gf180mcu_fd_sc_mcu7t5v0__fillcap_8
XFILLER_63_137 VDD VDD VSS VSS gf180mcu_fd_sc_mcu7t5v0__fill_2
XTAP_TAPCELL_ROW_74_699 VDD VSS gf180mcu_fd_sc_mcu7t5v0__filltie
X_2730_ _3949_/Q _3891_/Q _2743_/A1 VDD VDD VSS VSS gf180mcu_fd_sc_mcu7t5v0__nand2_1
XFILLER_8_241 VDD VDD VSS VSS gf180mcu_fd_sc_mcu7t5v0__fillcap_4
X_2661_ _4032_/Q _2873_/A2 _2669_/A2 _4031_/Q _2693_/A1 VDD VDD VSS VSS gf180mcu_fd_sc_mcu7t5v0__oai22_1
X_2592_ _2590_/B _2592_/A2 _2592_/B _2592_/C _2593_/B VDD VDD VSS VSS gf180mcu_fd_sc_mcu7t5v0__oai211_1
X_3213_ _3213_/A1 _3217_/A2 _3213_/B _4001_/D VDD VDD VSS VSS gf180mcu_fd_sc_mcu7t5v0__aoi21_1
X_3144_ _3751_/I1 _3151_/A2 wire81/Z _3145_/B VDD VDD VSS VSS gf180mcu_fd_sc_mcu7t5v0__oai21_1
X_3075_ _3751_/I1 _3080_/A2 wire81/Z _3076_/B VDD VDD VSS VSS gf180mcu_fd_sc_mcu7t5v0__oai21_1
XFILLER_39_178 VDD VDD VSS VSS gf180mcu_fd_sc_mcu7t5v0__fill_2
XFILLER_54_137 VDD VDD VSS VSS gf180mcu_fd_sc_mcu7t5v0__fillcap_4
X_2026_ _3841_/Q _3053_/A2 VDD VDD VSS VSS gf180mcu_fd_sc_mcu7t5v0__clkinv_1
XTAP_TAPCELL_ROW_65_644 VDD VSS gf180mcu_fd_sc_mcu7t5v0__filltie
XFILLER_35_362 VDD VDD VSS VSS gf180mcu_fd_sc_mcu7t5v0__fill_1
X_3977_ _3977_/D _4017_/CLK _3977_/Q VDD VDD VSS VSS gf180mcu_fd_sc_mcu7t5v0__dffq_1
X_2928_ hold156/Z _2928_/A2 _2929_/A2 VDD VDD VSS VSS gf180mcu_fd_sc_mcu7t5v0__nor2_1
X_2859_ _2857_/Z _2859_/A2 _2859_/Z VDD VDD VSS VSS gf180mcu_fd_sc_mcu7t5v0__xor2_1
Xhold230 _3930_/Q _2015_/I VDD VDD VSS VSS gf180mcu_fd_sc_mcu7t5v0__dlyc_1
XFILLER_104_323 VDD VDD VSS VSS gf180mcu_fd_sc_mcu7t5v0__fill_1
XFILLER_18_307 VDD VDD VSS VSS gf180mcu_fd_sc_mcu7t5v0__fill_2
XFILLER_85_240 VDD VDD VSS VSS gf180mcu_fd_sc_mcu7t5v0__fill_2
XFILLER_105_64 VDD VDD VSS VSS gf180mcu_fd_sc_mcu7t5v0__fillcap_4
XFILLER_105_53 VDD VDD VSS VSS gf180mcu_fd_sc_mcu7t5v0__fill_2
XFILLER_60_107 VDD VDD VSS VSS gf180mcu_fd_sc_mcu7t5v0__fillcap_8
XFILLER_26_384 VDD VDD VSS VSS gf180mcu_fd_sc_mcu7t5v0__fill_1
XFILLER_81_67 VDD VDD VSS VSS gf180mcu_fd_sc_mcu7t5v0__fill_2
XFILLER_14_94 VDD VDD VSS VSS gf180mcu_fd_sc_mcu7t5v0__fillcap_8
XTAP_TAPCELL_ROW_79_725 VDD VSS gf180mcu_fd_sc_mcu7t5v0__filltie
XFILLER_36_104 VDD VDD VSS VSS gf180mcu_fd_sc_mcu7t5v0__fill_1
XFILLER_91_232 VDD VDD VSS VSS gf180mcu_fd_sc_mcu7t5v0__fill_1
XTAP_TAPCELL_ROW_19_368 VDD VSS gf180mcu_fd_sc_mcu7t5v0__filltie
X_3900_ _3900_/D clkload9/I _3900_/Q VDD VDD VSS VSS gf180mcu_fd_sc_mcu7t5v0__dffq_1
XFILLER_32_321 VDD VDD VSS VSS gf180mcu_fd_sc_mcu7t5v0__fill_1
XTAP_TAPCELL_ROW_62_625 VDD VSS gf180mcu_fd_sc_mcu7t5v0__filltie
X_3831_ _3831_/D clkload6/I _3831_/Q VDD VDD VSS VSS gf180mcu_fd_sc_mcu7t5v0__dffq_1
X_3762_ _3762_/D _4142_/CLK _3762_/Q VDD VDD VSS VSS gf180mcu_fd_sc_mcu7t5v0__dffq_1
XFILLER_72_2 VDD VDD VSS VSS gf180mcu_fd_sc_mcu7t5v0__fillcap_8
X_2713_ _2760_/C _2713_/A2 _3887_/D VDD VDD VSS VSS gf180mcu_fd_sc_mcu7t5v0__nor2_1
X_3693_ _3754_/I1 _3678_/Z _3694_/A3 VDD VDD VSS VSS gf180mcu_fd_sc_mcu7t5v0__nand2_1
X_2644_ _3255_/A1 _3899_/Q _3898_/Q _3253_/A1 _2646_/A2 VDD VDD VSS VSS gf180mcu_fd_sc_mcu7t5v0__oai22_1
X_2575_ _2575_/A1 _2575_/A2 _2575_/A3 _2575_/B _2577_/B1 VDD VDD VSS VSS gf180mcu_fd_sc_mcu7t5v0__oai31_1
XFILLER_113_142 VDD VDD VSS VSS gf180mcu_fd_sc_mcu7t5v0__fillcap_4
XFILLER_101_304 VDD VDD VSS VSS gf180mcu_fd_sc_mcu7t5v0__fill_1
XFILLER_101_326 VDD VDD VSS VSS gf180mcu_fd_sc_mcu7t5v0__fillcap_4
X_3127_ _3751_/I1 _3138_/A2 wire81/Z _3128_/B VDD VDD VSS VSS gf180mcu_fd_sc_mcu7t5v0__oai21_1
XFILLER_67_284 VDD VDD VSS VSS gf180mcu_fd_sc_mcu7t5v0__fill_1
XFILLER_42_107 VDD VDD VSS VSS gf180mcu_fd_sc_mcu7t5v0__fillcap_32
X_3058_ _3286_/A1 _3080_/A2 wire81/Z _3059_/B VDD VDD VSS VSS gf180mcu_fd_sc_mcu7t5v0__oai21_1
X_2009_ _2009_/I _3074_/A1 VDD VDD VSS VSS gf180mcu_fd_sc_mcu7t5v0__clkinv_1
XTAP_TAPCELL_ROW_105_884 VDD VSS gf180mcu_fd_sc_mcu7t5v0__filltie
XFILLER_23_343 VDD VDD VSS VSS gf180mcu_fd_sc_mcu7t5v0__fillcap_4
XFILLER_50_162 VDD VDD VSS VSS gf180mcu_fd_sc_mcu7t5v0__fillcap_8
XFILLER_2_214 VDD VDD VSS VSS gf180mcu_fd_sc_mcu7t5v0__fill_1
XFILLER_2_247 VDD VDD VSS VSS gf180mcu_fd_sc_mcu7t5v0__fillcap_4
XTAP_TAPCELL_ROW_76_706 VDD VSS gf180mcu_fd_sc_mcu7t5v0__filltie
XFILLER_18_104 VDD VDD VSS VSS gf180mcu_fd_sc_mcu7t5v0__fill_1
XFILLER_58_273 VDD VDD VSS VSS gf180mcu_fd_sc_mcu7t5v0__fillcap_4
XFILLER_76_89 VDD VDD VSS VSS gf180mcu_fd_sc_mcu7t5v0__fillcap_4
XFILLER_73_221 VDD VDD VSS VSS gf180mcu_fd_sc_mcu7t5v0__fill_2
XFILLER_73_232 VDD VDD VSS VSS gf180mcu_fd_sc_mcu7t5v0__fillcap_16
XFILLER_33_118 VDD VDD VSS VSS gf180mcu_fd_sc_mcu7t5v0__fill_2
XFILLER_73_254 VDD VDD VSS VSS gf180mcu_fd_sc_mcu7t5v0__fill_1
Xclkbuf_leaf_9_ext_clk_in clkload0/I _4052_/CLK VDD VDD VSS VSS gf180mcu_fd_sc_mcu7t5v0__clkbuf_8
XFILLER_73_298 VDD VDD VSS VSS gf180mcu_fd_sc_mcu7t5v0__fillcap_16
XTAP_TAPCELL_ROW_16_349 VDD VSS gf180mcu_fd_sc_mcu7t5v0__filltie
XFILLER_14_387 VDD VDD VSS VSS gf180mcu_fd_sc_mcu7t5v0__fillcap_32
XFILLER_41_92 VDD VDD VSS VSS gf180mcu_fd_sc_mcu7t5v0__fillcap_4
XFILLER_44_6 VDD VDD VSS VSS gf180mcu_fd_sc_mcu7t5v0__fillcap_4
X_2360_ _2360_/A1 _2360_/A2 _2360_/A3 _2360_/Z VDD VDD VSS VSS gf180mcu_fd_sc_mcu7t5v0__or3_1
X_2291_ _2291_/I _3806_/D VDD VDD VSS VSS gf180mcu_fd_sc_mcu7t5v0__clkinv_1
XPHY_EDGE_ROW_10_Right_10 VDD VSS gf180mcu_fd_sc_mcu7t5v0__endcap
XFILLER_2_31 VDD VDD VSS VSS gf180mcu_fd_sc_mcu7t5v0__fillcap_4
X_4030_ _4030_/D _4166_/CLK _4030_/Q VDD VDD VSS VSS gf180mcu_fd_sc_mcu7t5v0__dffq_1
XTAP_TAPCELL_ROW_119_965 VDD VSS gf180mcu_fd_sc_mcu7t5v0__filltie
XFILLER_49_262 VDD VDD VSS VSS gf180mcu_fd_sc_mcu7t5v0__fill_1
XFILLER_64_287 VDD VDD VSS VSS gf180mcu_fd_sc_mcu7t5v0__fillcap_4
XTAP_TAPCELL_ROW_102_865 VDD VSS gf180mcu_fd_sc_mcu7t5v0__filltie
X_3814_ _3814_/D clkload6/I _3814_/Q VDD VDD VSS VSS gf180mcu_fd_sc_mcu7t5v0__dffq_1
XFILLER_118_212 VDD VDD VSS VSS gf180mcu_fd_sc_mcu7t5v0__fillcap_4
X_3745_ _4147_/Q _3725_/Z _3747_/A1 VDD VDD VSS VSS gf180mcu_fd_sc_mcu7t5v0__nor2_1
X_3676_ _4123_/Q _3676_/A2 _3746_/B _3677_/A2 VDD VDD VSS VSS gf180mcu_fd_sc_mcu7t5v0__nand3_1
X_2627_ _4010_/Q _2716_/A2 _2631_/B1 VDD VDD VSS VSS gf180mcu_fd_sc_mcu7t5v0__nand2_1
X_2558_ _3198_/A1 _3904_/Q _3903_/Q _3196_/A1 _2563_/B VDD VDD VSS VSS gf180mcu_fd_sc_mcu7t5v0__aoi22_1
X_2489_ _2495_/C _2489_/A2 _2488_/Z _2496_/B _2489_/C _2490_/B VDD VDD VSS VSS gf180mcu_fd_sc_mcu7t5v0__aoi221_1
XTAP_TAPCELL_ROW_98_842 VDD VSS gf180mcu_fd_sc_mcu7t5v0__filltie
XFILLER_101_123 VDD VDD VSS VSS gf180mcu_fd_sc_mcu7t5v0__fill_1
XFILLER_28_424 VDD VDD VSS VSS gf180mcu_fd_sc_mcu7t5v0__fill_2
XFILLER_46_15 VDD VDD VSS VSS gf180mcu_fd_sc_mcu7t5v0__fill_1
XFILLER_101_189 VDD VDD VSS VSS gf180mcu_fd_sc_mcu7t5v0__fill_1
X_4159_ _4159_/D clkload8/I _4159_/Q VDD VDD VSS VSS gf180mcu_fd_sc_mcu7t5v0__dffq_1
XFILLER_46_37 VDD VDD VSS VSS gf180mcu_fd_sc_mcu7t5v0__fillcap_8
XPHY_EDGE_ROW_106_Right_106 VDD VSS gf180mcu_fd_sc_mcu7t5v0__endcap
Xmax_cap49 _3090_/A2 _3104_/A2 VDD VDD VSS VSS gf180mcu_fd_sc_mcu7t5v0__buf_4
Xmax_cap38 _2111_/Z _2243_/A2 VDD VDD VSS VSS gf180mcu_fd_sc_mcu7t5v0__buf_12
XFILLER_102_54 VDD VDD VSS VSS gf180mcu_fd_sc_mcu7t5v0__fillcap_8
XFILLER_11_346 VDD VDD VSS VSS gf180mcu_fd_sc_mcu7t5v0__fillcap_4
XFILLER_109_212 VDD VDD VSS VSS gf180mcu_fd_sc_mcu7t5v0__fillcap_4
XFILLER_87_33 VDD VDD VSS VSS gf180mcu_fd_sc_mcu7t5v0__fill_1
XFILLER_87_88 VDD VDD VSS VSS gf180mcu_fd_sc_mcu7t5v0__fillcap_8
XTAP_TAPCELL_ROW_116_946 VDD VSS gf180mcu_fd_sc_mcu7t5v0__filltie
XFILLER_46_243 VDD VDD VSS VSS gf180mcu_fd_sc_mcu7t5v0__fill_2
XFILLER_36_92 VDD VDD VSS VSS gf180mcu_fd_sc_mcu7t5v0__fillcap_8
XFILLER_61_279 VDD VDD VSS VSS gf180mcu_fd_sc_mcu7t5v0__fill_1
X_3530_ _4096_/Q _3530_/A2 _3530_/B _3552_/C _4096_/D VDD VDD VSS VSS gf180mcu_fd_sc_mcu7t5v0__aoi211_1
X_3461_ _4147_/Q _3551_/A2 _3461_/Z VDD VDD VSS VSS gf180mcu_fd_sc_mcu7t5v0__and2_1
X_3392_ _3392_/A1 _3392_/A2 _3392_/A3 _3392_/A4 _3392_/Z VDD VDD VSS VSS gf180mcu_fd_sc_mcu7t5v0__and4_1
X_2412_ wire91/I wire51/Z _2404_/B _3810_/Q _2413_/I VDD VDD VSS VSS gf180mcu_fd_sc_mcu7t5v0__aoi22_1
X_2343_ _3819_/Q _2343_/I1 _2343_/S _2344_/I VDD VDD VSS VSS gf180mcu_fd_sc_mcu7t5v0__mux2_2
X_2274_ _4159_/Q _2319_/A2 _2339_/A1 VDD VDD VSS VSS gf180mcu_fd_sc_mcu7t5v0__nand2_1
X_4013_ _4013_/D clkload1/I _4013_/Q VDD VDD VSS VSS gf180mcu_fd_sc_mcu7t5v0__dffq_1
XTAP_TAPCELL_ROW_95_823 VDD VSS gf180mcu_fd_sc_mcu7t5v0__filltie
XFILLER_25_416 VDD VDD VSS VSS gf180mcu_fd_sc_mcu7t5v0__fillcap_4
XFILLER_16_18 VDD VDD VSS VSS gf180mcu_fd_sc_mcu7t5v0__fill_1
XFILLER_16_29 VDD VDD VSS VSS gf180mcu_fd_sc_mcu7t5v0__fill_1
XFILLER_20_132 VDD VDD VSS VSS gf180mcu_fd_sc_mcu7t5v0__fillcap_16
X_1989_ _3956_/Q _3117_/A1 VDD VDD VSS VSS gf180mcu_fd_sc_mcu7t5v0__clkinv_1
X_3728_ _3728_/A1 _3728_/A2 _3731_/C _4140_/D VDD VDD VSS VSS gf180mcu_fd_sc_mcu7t5v0__aoi21_1
Xclkbuf_0__1526_ _3527_/ZN clkbuf_0__1526_/Z VDD VDD VSS VSS gf180mcu_fd_sc_mcu7t5v0__clkbuf_16
X_3659_ _3659_/A1 _3659_/A2 _3659_/A3 _3660_/B2 VDD VDD VSS VSS gf180mcu_fd_sc_mcu7t5v0__nand3_1
XFILLER_106_259 VDD VDD VSS VSS gf180mcu_fd_sc_mcu7t5v0__fill_1
XFILLER_121_229 VDD VDD VSS VSS gf180mcu_fd_sc_mcu7t5v0__fillcap_8
XFILLER_57_69 VDD VDD VSS VSS gf180mcu_fd_sc_mcu7t5v0__fill_1
XFILLER_75_327 VDD VDD VSS VSS gf180mcu_fd_sc_mcu7t5v0__fill_2
XFILLER_28_243 VDD VDD VSS VSS gf180mcu_fd_sc_mcu7t5v0__fill_2
XFILLER_113_97 VDD VDD VSS VSS gf180mcu_fd_sc_mcu7t5v0__fill_2
XTAP_TAPCELL_ROW_26_411 VDD VSS gf180mcu_fd_sc_mcu7t5v0__filltie
XFILLER_31_419 VDD VDD VSS VSS gf180mcu_fd_sc_mcu7t5v0__fill_1
XFILLER_43_279 VDD VDD VSS VSS gf180mcu_fd_sc_mcu7t5v0__fill_1
Xwire91 wire91/I wire91/Z VDD VDD VSS VSS gf180mcu_fd_sc_mcu7t5v0__buf_4
XTAP_TAPCELL_ROW_121_982 VDD VSS gf180mcu_fd_sc_mcu7t5v0__filltie
XFILLER_112_207 VDD VDD VSS VSS gf180mcu_fd_sc_mcu7t5v0__fillcap_8
XFILLER_78_132 VDD VDD VSS VSS gf180mcu_fd_sc_mcu7t5v0__fillcap_32
XFILLER_66_327 VDD VDD VSS VSS gf180mcu_fd_sc_mcu7t5v0__fillcap_4
XTAP_TAPCELL_ROW_49_547 VDD VSS gf180mcu_fd_sc_mcu7t5v0__filltie
XFILLER_93_146 VDD VDD VSS VSS gf180mcu_fd_sc_mcu7t5v0__fill_1
XFILLER_19_265 VDD VDD VSS VSS gf180mcu_fd_sc_mcu7t5v0__fill_1
XTAP_TAPCELL_ROW_92_804 VDD VSS gf180mcu_fd_sc_mcu7t5v0__filltie
XFILLER_22_419 VDD VDD VSS VSS gf180mcu_fd_sc_mcu7t5v0__fillcap_4
X_2961_ _2961_/A1 _2961_/A2 _2961_/A3 _2962_/C VDD VDD VSS VSS gf180mcu_fd_sc_mcu7t5v0__nand3_1
XTAP_TAPCELL_ROW_32_447 VDD VSS gf180mcu_fd_sc_mcu7t5v0__filltie
XFILLER_42_290 VDD VDD VSS VSS gf180mcu_fd_sc_mcu7t5v0__fill_1
X_1912_ _4033_/Q _2683_/C VDD VDD VSS VSS gf180mcu_fd_sc_mcu7t5v0__clkinv_1
X_2892_ _2929_/A1 _2892_/A2 _3912_/D VDD VDD VSS VSS gf180mcu_fd_sc_mcu7t5v0__nor2_1
XTAP_TAPCELL_ROW_40_491 VDD VSS gf180mcu_fd_sc_mcu7t5v0__filltie
X_3513_ _4092_/Q _3513_/A2 _3536_/A2 _3520_/A2 _3515_/A1 VDD VDD VSS VSS gf180mcu_fd_sc_mcu7t5v0__aoi22_1
X_3444_ _4088_/Q _4087_/Q _4086_/Q _3446_/A2 VDD VDD VSS VSS gf180mcu_fd_sc_mcu7t5v0__nor3_1
X_3375_ _4136_/Q _3375_/A2 _4070_/Q _3696_/A1 _3387_/A1 VDD VDD VSS VSS gf180mcu_fd_sc_mcu7t5v0__aoi22_1
X_2326_ _3817_/Q _2328_/A2 _2327_/A2 VDD VDD VSS VSS gf180mcu_fd_sc_mcu7t5v0__nor2_1
X_2257_ _3822_/Q _3821_/Q _2257_/A3 _2319_/A2 VDD VDD VSS VSS gf180mcu_fd_sc_mcu7t5v0__nor3_1
XFILLER_72_308 VDD VDD VSS VSS gf180mcu_fd_sc_mcu7t5v0__fillcap_4
X_2188_ _4081_/Q _2242_/A2 _2190_/A1 VDD VDD VSS VSS gf180mcu_fd_sc_mcu7t5v0__nor2_1
XFILLER_102_251 VDD VDD VSS VSS gf180mcu_fd_sc_mcu7t5v0__fill_2
XFILLER_75_179 VDD VDD VSS VSS gf180mcu_fd_sc_mcu7t5v0__fill_2
XTAP_TAPCELL_ROW_46_528 VDD VSS gf180mcu_fd_sc_mcu7t5v0__filltie
XFILLER_17_72 VDD VDD VSS VSS gf180mcu_fd_sc_mcu7t5v0__fill_1
XFILLER_31_249 VDD VDD VSS VSS gf180mcu_fd_sc_mcu7t5v0__fillcap_8
XFILLER_8_423 VDD VDD VSS VSS gf180mcu_fd_sc_mcu7t5v0__fill_2
X_3160_ _3160_/A1 _3170_/A2 _3160_/B _3976_/D VDD VDD VSS VSS gf180mcu_fd_sc_mcu7t5v0__aoi21_1
X_3091_ _3848_/Q _3104_/A2 wire81/I _3092_/B VDD VDD VSS VSS gf180mcu_fd_sc_mcu7t5v0__oai21_1
XFILLER_66_135 VDD VDD VSS VSS gf180mcu_fd_sc_mcu7t5v0__fillcap_8
X_2111_ _2112_/A1 _3721_/A1 _2111_/Z VDD VDD VSS VSS gf180mcu_fd_sc_mcu7t5v0__and2_2
X_2042_ _3877_/Q _2542_/A1 VDD VDD VSS VSS gf180mcu_fd_sc_mcu7t5v0__clkinv_1
XFILLER_81_105 VDD VDD VSS VSS gf180mcu_fd_sc_mcu7t5v0__fill_2
XPHY_EDGE_ROW_8_Right_8 VDD VSS gf180mcu_fd_sc_mcu7t5v0__endcap
X_3993_ _3993_/D clkload2/I _3993_/Q VDD VDD VSS VSS gf180mcu_fd_sc_mcu7t5v0__dffq_1
X_2944_ _2957_/A1 _2943_/Z _3027_/C1 VDD VDD VSS VSS gf180mcu_fd_sc_mcu7t5v0__nor2_1
X_2875_ _2885_/A1 _2883_/A3 _2877_/A1 VDD VDD VSS VSS gf180mcu_fd_sc_mcu7t5v0__nand2_1
XFILLER_30_271 VDD VDD VSS VSS gf180mcu_fd_sc_mcu7t5v0__fill_2
X_3427_ _4074_/Q _3423_/Z _4075_/Q _3429_/A2 VDD VDD VSS VSS gf180mcu_fd_sc_mcu7t5v0__aoi21_1
XPHY_EDGE_ROW_39_Right_39 VDD VSS gf180mcu_fd_sc_mcu7t5v0__endcap
X_3358_ _3358_/I _4059_/D VDD VDD VSS VSS gf180mcu_fd_sc_mcu7t5v0__clkinv_1
X_2309_ _3833_/Q _2363_/A2 _2311_/B VDD VDD VSS VSS gf180mcu_fd_sc_mcu7t5v0__nand2_1
XFILLER_97_282 VDD VDD VSS VSS gf180mcu_fd_sc_mcu7t5v0__fillcap_8
X_3289_ _3289_/A1 _3291_/A2 _3289_/B _4037_/D VDD VDD VSS VSS gf180mcu_fd_sc_mcu7t5v0__aoi21_1
XFILLER_72_149 VDD VDD VSS VSS gf180mcu_fd_sc_mcu7t5v0__fillcap_8
XTAP_TAPCELL_ROW_43_509 VDD VSS gf180mcu_fd_sc_mcu7t5v0__filltie
XFILLER_13_227 VDD VDD VSS VSS gf180mcu_fd_sc_mcu7t5v0__fillcap_8
XPHY_EDGE_ROW_48_Right_48 VDD VSS gf180mcu_fd_sc_mcu7t5v0__endcap
XFILLER_110_65 VDD VDD VSS VSS gf180mcu_fd_sc_mcu7t5v0__fillcap_4
XFILLER_21_282 VDD VDD VSS VSS gf180mcu_fd_sc_mcu7t5v0__fill_2
XPHY_EDGE_ROW_57_Right_57 VDD VSS gf180mcu_fd_sc_mcu7t5v0__endcap
XFILLER_48_168 VDD VDD VSS VSS gf180mcu_fd_sc_mcu7t5v0__fill_2
XFILLER_28_71 VDD VDD VSS VSS gf180mcu_fd_sc_mcu7t5v0__fillcap_4
XFILLER_36_319 VDD VDD VSS VSS gf180mcu_fd_sc_mcu7t5v0__fill_1
XPHY_EDGE_ROW_66_Right_66 VDD VSS gf180mcu_fd_sc_mcu7t5v0__endcap
XFILLER_12_260 VDD VDD VSS VSS gf180mcu_fd_sc_mcu7t5v0__fill_1
X_2660_ _3279_/A1 _3910_/Q _3909_/Q _3277_/A1 _2675_/A1 VDD VDD VSS VSS gf180mcu_fd_sc_mcu7t5v0__aoi22_1
XFILLER_60_91 VDD VDD VSS VSS gf180mcu_fd_sc_mcu7t5v0__fill_2
X_2591_ _3181_/A1 _3896_/Q _3895_/Q _2591_/C _2592_/B VDD VDD VSS VSS gf180mcu_fd_sc_mcu7t5v0__oai211_1
XPHY_EDGE_ROW_75_Right_75 VDD VSS gf180mcu_fd_sc_mcu7t5v0__endcap
X_3212_ _3751_/I1 _3217_/A2 wire81/Z _3213_/B VDD VDD VSS VSS gf180mcu_fd_sc_mcu7t5v0__oai21_1
XFILLER_39_124 VDD VDD VSS VSS gf180mcu_fd_sc_mcu7t5v0__fill_2
XFILLER_67_422 VDD VDD VSS VSS gf180mcu_fd_sc_mcu7t5v0__fillcap_4
XFILLER_39_146 VDD VDD VSS VSS gf180mcu_fd_sc_mcu7t5v0__fill_2
XFILLER_94_230 VDD VDD VSS VSS gf180mcu_fd_sc_mcu7t5v0__fillcap_8
X_3143_ _3143_/A1 _3151_/A2 _3143_/B _3968_/D VDD VDD VSS VSS gf180mcu_fd_sc_mcu7t5v0__aoi21_1
XPHY_EDGE_ROW_84_Right_84 VDD VSS gf180mcu_fd_sc_mcu7t5v0__endcap
X_3074_ _3074_/A1 _3082_/A2 _3074_/B _3936_/D VDD VDD VSS VSS gf180mcu_fd_sc_mcu7t5v0__aoi21_1
XFILLER_94_263 VDD VDD VSS VSS gf180mcu_fd_sc_mcu7t5v0__fill_1
X_2025_ _3845_/Q _3676_/A2 VDD VDD VSS VSS gf180mcu_fd_sc_mcu7t5v0__clkinv_1
XTAP_TAPCELL_ROW_65_645 VDD VSS gf180mcu_fd_sc_mcu7t5v0__filltie
X_3976_ _3976_/D clkload1/I _3976_/Q VDD VDD VSS VSS gf180mcu_fd_sc_mcu7t5v0__dffq_1
X_2927_ _2760_/C _2925_/Z _2927_/A3 _3917_/D VDD VDD VSS VSS gf180mcu_fd_sc_mcu7t5v0__nor3_1
XFILLER_108_107 VDD VDD VSS VSS gf180mcu_fd_sc_mcu7t5v0__fill_1
XPHY_EDGE_ROW_93_Right_93 VDD VSS gf180mcu_fd_sc_mcu7t5v0__endcap
X_2858_ _2848_/Z _2858_/A2 _2858_/B _2859_/A2 VDD VDD VSS VSS gf180mcu_fd_sc_mcu7t5v0__aoi21_1
X_2789_ _3956_/Q _3898_/Q _3897_/Q _3955_/Q _2802_/A3 VDD VDD VSS VSS gf180mcu_fd_sc_mcu7t5v0__aoi22_1
Xhold220 _4019_/Q _1926_/I VDD VDD VSS VSS gf180mcu_fd_sc_mcu7t5v0__dlyc_1
Xhold231 _4110_/Q hold231/Z VDD VDD VSS VSS gf180mcu_fd_sc_mcu7t5v0__dlyc_1
XFILLER_105_32 VDD VDD VSS VSS gf180mcu_fd_sc_mcu7t5v0__fillcap_4
XFILLER_45_116 VDD VDD VSS VSS gf180mcu_fd_sc_mcu7t5v0__fill_1
XFILLER_85_263 VDD VDD VSS VSS gf180mcu_fd_sc_mcu7t5v0__fill_2
XFILLER_105_76 VDD VDD VSS VSS gf180mcu_fd_sc_mcu7t5v0__fill_2
XFILLER_45_138 VDD VDD VSS VSS gf180mcu_fd_sc_mcu7t5v0__fill_2
XFILLER_26_374 VDD VDD VSS VSS gf180mcu_fd_sc_mcu7t5v0__fillcap_8
XFILLER_14_62 VDD VDD VSS VSS gf180mcu_fd_sc_mcu7t5v0__fill_1
XFILLER_30_50 VDD VDD VSS VSS gf180mcu_fd_sc_mcu7t5v0__fill_1
XFILLER_5_278 VDD VDD VSS VSS gf180mcu_fd_sc_mcu7t5v0__fill_2
XFILLER_107_184 VDD VDD VSS VSS gf180mcu_fd_sc_mcu7t5v0__fillcap_4
XFILLER_49_422 VDD VDD VSS VSS gf180mcu_fd_sc_mcu7t5v0__fillcap_4
XTAP_TAPCELL_ROW_79_726 VDD VSS gf180mcu_fd_sc_mcu7t5v0__filltie
XFILLER_64_425 VDD VDD VSS VSS gf180mcu_fd_sc_mcu7t5v0__fill_1
XFILLER_17_330 VDD VDD VSS VSS gf180mcu_fd_sc_mcu7t5v0__fill_2
XFILLER_76_296 VDD VDD VSS VSS gf180mcu_fd_sc_mcu7t5v0__fill_1
XTAP_TAPCELL_ROW_19_369 VDD VSS gf180mcu_fd_sc_mcu7t5v0__filltie
XFILLER_17_352 VDD VDD VSS VSS gf180mcu_fd_sc_mcu7t5v0__fillcap_64
XFILLER_44_171 VDD VDD VSS VSS gf180mcu_fd_sc_mcu7t5v0__fillcap_4
XTAP_TAPCELL_ROW_62_626 VDD VSS gf180mcu_fd_sc_mcu7t5v0__filltie
X_3830_ _3830_/D clkload6/I _3830_/Q VDD VDD VSS VSS gf180mcu_fd_sc_mcu7t5v0__dffq_1
XFILLER_44_193 VDD VDD VSS VSS gf180mcu_fd_sc_mcu7t5v0__fillcap_4
XTAP_TAPCELL_ROW_70_670 VDD VSS gf180mcu_fd_sc_mcu7t5v0__filltie
X_3761_ _3761_/D _4058_/CLK _3761_/Q VDD VDD VSS VSS gf180mcu_fd_sc_mcu7t5v0__dffq_1
X_2712_ _2709_/Z _2720_/B2 _2713_/A2 VDD VDD VSS VSS gf180mcu_fd_sc_mcu7t5v0__xnor2_1
X_3692_ _4129_/Q _3692_/A2 _3694_/A2 VDD VDD VSS VSS gf180mcu_fd_sc_mcu7t5v0__nand2_1
X_2643_ _4021_/Q _2598_/B _2643_/B1 _4020_/Q _2645_/A4 VDD VDD VSS VSS gf180mcu_fd_sc_mcu7t5v0__aoi22_1
XFILLER_65_2 VDD VDD VSS VSS gf180mcu_fd_sc_mcu7t5v0__fillcap_4
X_2574_ _3978_/Q _2716_/A2 _2714_/A2 _3977_/Q _2575_/B VDD VDD VSS VSS gf180mcu_fd_sc_mcu7t5v0__aoi22_1
XFILLER_19_18 VDD VDD VSS VSS gf180mcu_fd_sc_mcu7t5v0__fillcap_8
X_3126_ _3126_/A1 _3138_/A2 _3126_/B _3960_/D VDD VDD VSS VSS gf180mcu_fd_sc_mcu7t5v0__aoi21_1
XFILLER_27_138 VDD VDD VSS VSS gf180mcu_fd_sc_mcu7t5v0__fill_2
XFILLER_82_244 VDD VDD VSS VSS gf180mcu_fd_sc_mcu7t5v0__fill_1
X_3057_ _3057_/A1 _3275_/A2 _3080_/A2 VDD VDD VSS VSS gf180mcu_fd_sc_mcu7t5v0__nand2_1
X_2008_ _2008_/I _3076_/A1 VDD VDD VSS VSS gf180mcu_fd_sc_mcu7t5v0__clkinv_1
XTAP_TAPCELL_ROW_105_885 VDD VSS gf180mcu_fd_sc_mcu7t5v0__filltie
XFILLER_50_174 VDD VDD VSS VSS gf180mcu_fd_sc_mcu7t5v0__fill_1
X_3959_ _3959_/D _4034_/CLK _3959_/Q VDD VDD VSS VSS gf180mcu_fd_sc_mcu7t5v0__dffq_1
XFILLER_51_38 VDD VDD VSS VSS gf180mcu_fd_sc_mcu7t5v0__fill_2
XFILLER_104_143 VDD VDD VSS VSS gf180mcu_fd_sc_mcu7t5v0__fill_1
XTAP_TAPCELL_ROW_76_707 VDD VSS gf180mcu_fd_sc_mcu7t5v0__filltie
XFILLER_58_263 VDD VDD VSS VSS gf180mcu_fd_sc_mcu7t5v0__fill_1
XFILLER_92_89 VDD VDD VSS VSS gf180mcu_fd_sc_mcu7t5v0__fill_2
XTAP_TAPCELL_ROW_24_394 VDD VSS gf180mcu_fd_sc_mcu7t5v0__filltie
XFILLER_115_419 VDD VDD VSS VSS gf180mcu_fd_sc_mcu7t5v0__fill_1
X_2290_ _2290_/A1 _2290_/A2 _2290_/A3 _2290_/B1 _3806_/Q _2291_/I VDD VDD VSS VSS
+ gf180mcu_fd_sc_mcu7t5v0__oai32_1
XFILLER_96_314 VDD VDD VSS VSS gf180mcu_fd_sc_mcu7t5v0__fill_1
XFILLER_96_369 VDD VDD VSS VSS gf180mcu_fd_sc_mcu7t5v0__fillcap_4
XTAP_TAPCELL_ROW_119_966 VDD VSS gf180mcu_fd_sc_mcu7t5v0__filltie
X_3813_ _3813_/D clkload7/I _3813_/Q VDD VDD VSS VSS gf180mcu_fd_sc_mcu7t5v0__dffq_1
XTAP_TAPCELL_ROW_102_866 VDD VSS gf180mcu_fd_sc_mcu7t5v0__filltie
X_3744_ _3744_/A1 _3746_/A2 _3744_/B _4146_/D VDD VDD VSS VSS gf180mcu_fd_sc_mcu7t5v0__aoi21_1
X_3675_ _3587_/B _3675_/A2 _3675_/A3 _3677_/A1 VDD VDD VSS VSS gf180mcu_fd_sc_mcu7t5v0__nand3_1
X_2626_ _4013_/Q _2746_/A2 _2634_/B1 VDD VDD VSS VSS gf180mcu_fd_sc_mcu7t5v0__nand2_1
XFILLER_106_419 VDD VDD VSS VSS gf180mcu_fd_sc_mcu7t5v0__fillcap_4
Xclkbuf_0__1473_ _3459_/ZN clkbuf_0__1473_/Z VDD VDD VSS VSS gf180mcu_fd_sc_mcu7t5v0__clkbuf_16
X_2557_ _3881_/Q _2557_/A2 _3882_/D VDD VDD VSS VSS gf180mcu_fd_sc_mcu7t5v0__and2_1
X_2488_ _4119_/Q _3922_/Q _2488_/Z VDD VDD VSS VSS gf180mcu_fd_sc_mcu7t5v0__or2_1
XFILLER_87_358 VDD VDD VSS VSS gf180mcu_fd_sc_mcu7t5v0__fill_1
XTAP_TAPCELL_ROW_98_843 VDD VSS gf180mcu_fd_sc_mcu7t5v0__filltie
XFILLER_101_157 VDD VDD VSS VSS gf180mcu_fd_sc_mcu7t5v0__fill_1
X_4158_ _4158_/D clkload8/I _4158_/Q VDD VDD VSS VSS gf180mcu_fd_sc_mcu7t5v0__dffq_1
XFILLER_46_49 VDD VDD VSS VSS gf180mcu_fd_sc_mcu7t5v0__fill_2
X_3109_ _3109_/A1 _3121_/A2 _3109_/B _3952_/D VDD VDD VSS VSS gf180mcu_fd_sc_mcu7t5v0__aoi21_1
XFILLER_15_108 VDD VDD VSS VSS gf180mcu_fd_sc_mcu7t5v0__fill_2
X_4089_ _4089_/D clkload5/I _4089_/Q VDD VDD VSS VSS gf180mcu_fd_sc_mcu7t5v0__dffq_1
Xmax_cap39 _3650_/B1 _3669_/B1 VDD VDD VSS VSS gf180mcu_fd_sc_mcu7t5v0__clkbuf_2
XFILLER_70_247 VDD VDD VSS VSS gf180mcu_fd_sc_mcu7t5v0__fill_1
XFILLER_102_66 VDD VDD VSS VSS gf180mcu_fd_sc_mcu7t5v0__fill_2
XFILLER_23_174 VDD VDD VSS VSS gf180mcu_fd_sc_mcu7t5v0__fillcap_8
XFILLER_11_74 VDD VDD VSS VSS gf180mcu_fd_sc_mcu7t5v0__fill_1
XFILLER_78_303 VDD VDD VSS VSS gf180mcu_fd_sc_mcu7t5v0__fillcap_4
XFILLER_19_414 VDD VDD VSS VSS gf180mcu_fd_sc_mcu7t5v0__fillcap_4
XFILLER_46_222 VDD VDD VSS VSS gf180mcu_fd_sc_mcu7t5v0__fill_1
XTAP_TAPCELL_ROW_116_947 VDD VSS gf180mcu_fd_sc_mcu7t5v0__filltie
X_2411_ _2411_/I _3849_/D VDD VDD VSS VSS gf180mcu_fd_sc_mcu7t5v0__clkinv_1
X_3391_ _4067_/Q _4066_/Q _4065_/Q _4064_/Q _3392_/A4 VDD VDD VSS VSS gf180mcu_fd_sc_mcu7t5v0__nor4_1
XFILLER_111_422 VDD VDD VSS VSS gf180mcu_fd_sc_mcu7t5v0__fillcap_4
X_2342_ _3834_/Q _2342_/A2 _2342_/B _2343_/I1 VDD VDD VSS VSS gf180mcu_fd_sc_mcu7t5v0__oai21_1
X_2273_ _4159_/Q _2319_/A2 _2273_/Z VDD VDD VSS VSS gf180mcu_fd_sc_mcu7t5v0__and2_1
X_4012_ _4012_/D _4017_/CLK _4012_/Q VDD VDD VSS VSS gf180mcu_fd_sc_mcu7t5v0__dffq_1
XFILLER_84_317 VDD VDD VSS VSS gf180mcu_fd_sc_mcu7t5v0__fillcap_4
XTAP_TAPCELL_ROW_95_824 VDD VSS gf180mcu_fd_sc_mcu7t5v0__filltie
XFILLER_96_166 VDD VDD VSS VSS gf180mcu_fd_sc_mcu7t5v0__fillcap_8
XFILLER_96_177 VDD VDD VSS VSS gf180mcu_fd_sc_mcu7t5v0__fillcap_8
XFILLER_52_247 VDD VDD VSS VSS gf180mcu_fd_sc_mcu7t5v0__fillcap_4
X_1988_ _3957_/Q _3119_/A1 VDD VDD VSS VSS gf180mcu_fd_sc_mcu7t5v0__clkinv_1
X_3727_ wire94/Z _3725_/Z _3728_/A2 VDD VDD VSS VSS gf180mcu_fd_sc_mcu7t5v0__nand2_1
X_3658_ _4199_/I _3748_/A1 _3726_/A1 _4141_/Q _3659_/A3 VDD VDD VSS VSS gf180mcu_fd_sc_mcu7t5v0__aoi22_1
X_3589_ _3592_/A1 _2943_/Z _3663_/A2 VDD VDD VSS VSS gf180mcu_fd_sc_mcu7t5v0__nor2_1
X_2609_ _3219_/A1 _3914_/Q _2622_/B VDD VDD VSS VSS gf180mcu_fd_sc_mcu7t5v0__nand2_1
XFILLER_87_100 VDD VDD VSS VSS gf180mcu_fd_sc_mcu7t5v0__fill_1
XFILLER_102_422 VDD VDD VSS VSS gf180mcu_fd_sc_mcu7t5v0__fillcap_4
XFILLER_28_222 VDD VDD VSS VSS gf180mcu_fd_sc_mcu7t5v0__fillcap_4
XFILLER_90_309 VDD VDD VSS VSS gf180mcu_fd_sc_mcu7t5v0__fillcap_4
XTAP_TAPCELL_ROW_113_928 VDD VSS gf180mcu_fd_sc_mcu7t5v0__filltie
Xwire81 wire81/I wire81/Z VDD VDD VSS VSS gf180mcu_fd_sc_mcu7t5v0__buf_16
XFILLER_73_69 VDD VDD VSS VSS gf180mcu_fd_sc_mcu7t5v0__fill_1
XTAP_TAPCELL_ROW_121_983 VDD VSS gf180mcu_fd_sc_mcu7t5v0__filltie
XFILLER_7_104 VDD VDD VSS VSS gf180mcu_fd_sc_mcu7t5v0__fillcap_16
XFILLER_7_126 VDD VDD VSS VSS gf180mcu_fd_sc_mcu7t5v0__fill_1
XFILLER_22_73 VDD VDD VSS VSS gf180mcu_fd_sc_mcu7t5v0__fillcap_32
XFILLER_7_159 VDD VDD VSS VSS gf180mcu_fd_sc_mcu7t5v0__fill_1
XFILLER_112_219 VDD VDD VSS VSS gf180mcu_fd_sc_mcu7t5v0__fill_2
XFILLER_105_282 VDD VDD VSS VSS gf180mcu_fd_sc_mcu7t5v0__fillcap_8
XFILLER_78_166 VDD VDD VSS VSS gf180mcu_fd_sc_mcu7t5v0__fill_1
XTAP_TAPCELL_ROW_49_548 VDD VSS gf180mcu_fd_sc_mcu7t5v0__filltie
XFILLER_47_81 VDD VDD VSS VSS gf180mcu_fd_sc_mcu7t5v0__fill_1
XTAP_TAPCELL_ROW_92_805 VDD VSS gf180mcu_fd_sc_mcu7t5v0__filltie
XTAP_TAPCELL_ROW_57_592 VDD VSS gf180mcu_fd_sc_mcu7t5v0__filltie
X_2960_ _3961_/Q _3122_/A1 _3258_/A1 _4025_/Q _2961_/A3 VDD VDD VSS VSS gf180mcu_fd_sc_mcu7t5v0__aoi22_1
X_2891_ _2891_/A1 _2891_/A2 _2892_/A2 VDD VDD VSS VSS gf180mcu_fd_sc_mcu7t5v0__xnor2_1
X_1911_ _4034_/Q _3283_/A1 VDD VDD VSS VSS gf180mcu_fd_sc_mcu7t5v0__clkinv_1
XTAP_TAPCELL_ROW_40_492 VDD VSS gf180mcu_fd_sc_mcu7t5v0__filltie
X_3512_ _4092_/Q _3508_/I _3520_/A2 VDD VDD VSS VSS gf180mcu_fd_sc_mcu7t5v0__nand2_1
X_3443_ _4084_/Q _3443_/A2 _4085_/Q _3446_/A1 VDD VDD VSS VSS gf180mcu_fd_sc_mcu7t5v0__oai21_1
X_3374_ _3711_/A1 _4076_/Q _3374_/B1 _4133_/Q _3380_/C VDD VDD VSS VSS gf180mcu_fd_sc_mcu7t5v0__aoi22_1
XFILLER_111_241 VDD VDD VSS VSS gf180mcu_fd_sc_mcu7t5v0__fill_2
X_2325_ hold171/Z _2273_/Z _2325_/S _3816_/D VDD VDD VSS VSS gf180mcu_fd_sc_mcu7t5v0__mux2_2
XFILLER_69_155 VDD VDD VSS VSS gf180mcu_fd_sc_mcu7t5v0__fillcap_16
X_2256_ _3822_/Q _3821_/Q _2354_/A1 VDD VDD VSS VSS gf180mcu_fd_sc_mcu7t5v0__nor2_1
XFILLER_65_361 VDD VDD VSS VSS gf180mcu_fd_sc_mcu7t5v0__fill_1
X_2187_ _2187_/A1 _2187_/A2 _3782_/D VDD VDD VSS VSS gf180mcu_fd_sc_mcu7t5v0__nor2_1
XFILLER_40_206 VDD VDD VSS VSS gf180mcu_fd_sc_mcu7t5v0__fillcap_4
XFILLER_40_239 VDD VDD VSS VSS gf180mcu_fd_sc_mcu7t5v0__fillcap_4
XFILLER_119_352 VDD VDD VSS VSS gf180mcu_fd_sc_mcu7t5v0__fillcap_64
XFILLER_4_107 VDD VDD VSS VSS gf180mcu_fd_sc_mcu7t5v0__fill_2
XFILLER_104_6 VDD VDD VSS VSS gf180mcu_fd_sc_mcu7t5v0__fill_1
XFILLER_88_420 VDD VDD VSS VSS gf180mcu_fd_sc_mcu7t5v0__fillcap_4
XFILLER_102_230 VDD VDD VSS VSS gf180mcu_fd_sc_mcu7t5v0__fillcap_4
XFILLER_102_274 VDD VDD VSS VSS gf180mcu_fd_sc_mcu7t5v0__fill_2
XTAP_TAPCELL_ROW_46_529 VDD VSS gf180mcu_fd_sc_mcu7t5v0__filltie
XFILLER_16_247 VDD VDD VSS VSS gf180mcu_fd_sc_mcu7t5v0__fill_1
XFILLER_33_72 VDD VDD VSS VSS gf180mcu_fd_sc_mcu7t5v0__fillcap_4
XPHY_EDGE_ROW_49_Left_171 VDD VSS gf180mcu_fd_sc_mcu7t5v0__endcap
XFILLER_98_239 VDD VDD VSS VSS gf180mcu_fd_sc_mcu7t5v0__fillcap_4
X_3090_ _3090_/A1 _3090_/A2 _3090_/B _3943_/D VDD VDD VSS VSS gf180mcu_fd_sc_mcu7t5v0__aoi21_1
XPHY_EDGE_ROW_58_Left_180 VDD VSS gf180mcu_fd_sc_mcu7t5v0__endcap
XFILLER_66_103 VDD VDD VSS VSS gf180mcu_fd_sc_mcu7t5v0__fill_2
X_2110_ _3720_/A1 _2110_/A2 _3587_/B _3721_/A1 VDD VDD VSS VSS gf180mcu_fd_sc_mcu7t5v0__oai21_1
X_2041_ _3871_/Q _2525_/A2 VDD VDD VSS VSS gf180mcu_fd_sc_mcu7t5v0__clkinv_1
X_3992_ _3992_/D clkload2/I _3992_/Q VDD VDD VSS VSS gf180mcu_fd_sc_mcu7t5v0__dffq_1
X_2943_ _3838_/Q _3837_/Q _2943_/Z VDD VDD VSS VSS gf180mcu_fd_sc_mcu7t5v0__or2_1
XFILLER_95_2 VDD VDD VSS VSS gf180mcu_fd_sc_mcu7t5v0__fill_1
X_2874_ _3968_/Q _3910_/Q _2883_/A3 VDD VDD VSS VSS gf180mcu_fd_sc_mcu7t5v0__nand2_1
X_3426_ _4074_/Q _3423_/Z _3426_/B _4074_/D VDD VDD VSS VSS gf180mcu_fd_sc_mcu7t5v0__aoi21_1
X_3357_ _4059_/Q _3354_/Z _3357_/B _3358_/I VDD VDD VSS VSS gf180mcu_fd_sc_mcu7t5v0__oai21_1
X_2308_ _2548_/A1 _2300_/S _2308_/B _3814_/D VDD VDD VSS VSS gf180mcu_fd_sc_mcu7t5v0__aoi21_1
XFILLER_57_125 VDD VDD VSS VSS gf180mcu_fd_sc_mcu7t5v0__fillcap_8
XFILLER_97_294 VDD VDD VSS VSS gf180mcu_fd_sc_mcu7t5v0__fill_1
X_3288_ _3288_/A1 _3291_/A2 wire81/Z _3289_/B VDD VDD VSS VSS gf180mcu_fd_sc_mcu7t5v0__oai21_1
X_2239_ _4100_/Q _2248_/A2 _2241_/A1 VDD VDD VSS VSS gf180mcu_fd_sc_mcu7t5v0__nor2_1
XFILLER_13_239 VDD VDD VSS VSS gf180mcu_fd_sc_mcu7t5v0__fill_2
XFILLER_80_172 VDD VDD VSS VSS gf180mcu_fd_sc_mcu7t5v0__fill_2
XFILLER_21_272 VDD VDD VSS VSS gf180mcu_fd_sc_mcu7t5v0__fill_1
XFILLER_21_261 VDD VDD VSS VSS gf180mcu_fd_sc_mcu7t5v0__fillcap_4
XFILLER_70_37 VDD VDD VSS VSS gf180mcu_fd_sc_mcu7t5v0__fillcap_16
XFILLER_119_171 VDD VDD VSS VSS gf180mcu_fd_sc_mcu7t5v0__fillcap_8
XFILLER_5_416 VDD VDD VSS VSS gf180mcu_fd_sc_mcu7t5v0__fillcap_4
XFILLER_107_366 VDD VDD VSS VSS gf180mcu_fd_sc_mcu7t5v0__fillcap_4
XFILLER_95_209 VDD VDD VSS VSS gf180mcu_fd_sc_mcu7t5v0__fill_1
XTAP_TAPCELL_ROW_8_298 VDD VSS gf180mcu_fd_sc_mcu7t5v0__filltie
XFILLER_28_83 VDD VDD VSS VSS gf180mcu_fd_sc_mcu7t5v0__fillcap_16
XFILLER_63_139 VDD VDD VSS VSS gf180mcu_fd_sc_mcu7t5v0__fill_1
XFILLER_44_375 VDD VDD VSS VSS gf180mcu_fd_sc_mcu7t5v0__fill_2
X_2590_ _2590_/A1 _2590_/A2 _2590_/B _2590_/C _2597_/A1 VDD VDD VSS VSS gf180mcu_fd_sc_mcu7t5v0__aoi211_1
XFILLER_113_314 VDD VDD VSS VSS gf180mcu_fd_sc_mcu7t5v0__fill_1
X_3211_ _3211_/A1 _3217_/A2 _3211_/B _4000_/D VDD VDD VSS VSS gf180mcu_fd_sc_mcu7t5v0__aoi21_1
X_3142_ _3750_/I1 _3151_/A2 wire81/Z _3143_/B VDD VDD VSS VSS gf180mcu_fd_sc_mcu7t5v0__oai21_1
X_3073_ wire91/Z _3082_/A2 wire81/Z _3074_/B VDD VDD VSS VSS gf180mcu_fd_sc_mcu7t5v0__oai21_1
XFILLER_54_128 VDD VDD VSS VSS gf180mcu_fd_sc_mcu7t5v0__fill_2
X_2024_ _3846_/Q _3667_/C2 VDD VDD VSS VSS gf180mcu_fd_sc_mcu7t5v0__clkinv_1
X_3975_ _3975_/D clkload1/I _3975_/Q VDD VDD VSS VSS gf180mcu_fd_sc_mcu7t5v0__dffq_1
XTAP_TAPCELL_ROW_73_690 VDD VSS gf180mcu_fd_sc_mcu7t5v0__filltie
X_2926_ _2926_/A1 _2924_/Z _2926_/B _2927_/A3 VDD VDD VSS VSS gf180mcu_fd_sc_mcu7t5v0__aoi21_1
X_2857_ _3966_/Q _3908_/Q _2857_/Z VDD VDD VSS VSS gf180mcu_fd_sc_mcu7t5v0__xor2_1
X_2788_ _2791_/B _2792_/A1 VDD VDD VSS VSS gf180mcu_fd_sc_mcu7t5v0__clkinv_1
Xhold210 _3978_/Q _1967_/I VDD VDD VSS VSS gf180mcu_fd_sc_mcu7t5v0__dlyc_1
XFILLER_116_152 VDD VDD VSS VSS gf180mcu_fd_sc_mcu7t5v0__fill_2
XFILLER_2_419 VDD VDD VSS VSS gf180mcu_fd_sc_mcu7t5v0__fillcap_4
Xhold221 _3936_/Q _2009_/I VDD VDD VSS VSS gf180mcu_fd_sc_mcu7t5v0__dlyc_1
Xhold232 _4058_/Q hold232/Z VDD VDD VSS VSS gf180mcu_fd_sc_mcu7t5v0__dlyc_1
XFILLER_104_314 VDD VDD VSS VSS gf180mcu_fd_sc_mcu7t5v0__fill_1
XFILLER_116_174 VDD VDD VSS VSS gf180mcu_fd_sc_mcu7t5v0__fill_1
XFILLER_116_185 VDD VDD VSS VSS gf180mcu_fd_sc_mcu7t5v0__fillcap_4
XFILLER_104_336 VDD VDD VSS VSS gf180mcu_fd_sc_mcu7t5v0__fill_2
X_3409_ _4067_/Q _3404_/Z _4068_/Q _3411_/A2 VDD VDD VSS VSS gf180mcu_fd_sc_mcu7t5v0__aoi21_1
XFILLER_49_49 VDD VDD VSS VSS gf180mcu_fd_sc_mcu7t5v0__fillcap_8
XFILLER_105_22 VDD VDD VSS VSS gf180mcu_fd_sc_mcu7t5v0__fill_2
XFILLER_85_242 VDD VDD VSS VSS gf180mcu_fd_sc_mcu7t5v0__fill_1
XFILLER_18_309 VDD VDD VSS VSS gf180mcu_fd_sc_mcu7t5v0__fill_1
XFILLER_105_88 VDD VDD VSS VSS gf180mcu_fd_sc_mcu7t5v0__fillcap_32
XFILLER_41_345 VDD VDD VSS VSS gf180mcu_fd_sc_mcu7t5v0__fillcap_4
XFILLER_81_69 VDD VDD VSS VSS gf180mcu_fd_sc_mcu7t5v0__fill_1
XFILLER_110_317 VDD VDD VSS VSS gf180mcu_fd_sc_mcu7t5v0__fill_2
XTAP_TAPCELL_ROW_79_727 VDD VSS gf180mcu_fd_sc_mcu7t5v0__filltie
XFILLER_36_139 VDD VDD VSS VSS gf180mcu_fd_sc_mcu7t5v0__fill_1
XFILLER_91_212 VDD VDD VSS VSS gf180mcu_fd_sc_mcu7t5v0__fillcap_4
XTAP_TAPCELL_ROW_62_627 VDD VSS gf180mcu_fd_sc_mcu7t5v0__filltie
XTAP_TAPCELL_ROW_70_671 VDD VSS gf180mcu_fd_sc_mcu7t5v0__filltie
X_3760_ _3760_/D _4142_/CLK _3760_/Q VDD VDD VSS VSS gf180mcu_fd_sc_mcu7t5v0__dffq_1
X_2711_ _2709_/Z _2720_/B2 _2714_/B VDD VDD VSS VSS gf180mcu_fd_sc_mcu7t5v0__nand2_1
XFILLER_71_80 VDD VDD VSS VSS gf180mcu_fd_sc_mcu7t5v0__fillcap_4
X_3691_ _3691_/A1 _3691_/A2 _4128_/D VDD VDD VSS VSS gf180mcu_fd_sc_mcu7t5v0__nor2_1
X_2642_ _3257_/A1 _3900_/Q _3899_/Q _3255_/A1 _2646_/B VDD VDD VSS VSS gf180mcu_fd_sc_mcu7t5v0__aoi22_1
X_2573_ _3976_/Q _2706_/A2 _2573_/B1 _3975_/Q _2575_/A3 VDD VDD VSS VSS gf180mcu_fd_sc_mcu7t5v0__aoi22_1
X_3125_ _3750_/I1 _3138_/A2 wire81/Z _3126_/B VDD VDD VSS VSS gf180mcu_fd_sc_mcu7t5v0__oai21_1
X_3056_ _3731_/C _3056_/A2 _3928_/D VDD VDD VSS VSS gf180mcu_fd_sc_mcu7t5v0__nor2_1
XFILLER_35_18 VDD VDD VSS VSS gf180mcu_fd_sc_mcu7t5v0__fill_1
X_2007_ _2007_/I _3078_/A1 VDD VDD VSS VSS gf180mcu_fd_sc_mcu7t5v0__clkinv_1
XFILLER_50_131 VDD VDD VSS VSS gf180mcu_fd_sc_mcu7t5v0__fill_2
X_3958_ _3958_/D clkload9/I _3958_/Q VDD VDD VSS VSS gf180mcu_fd_sc_mcu7t5v0__dffq_1
XFILLER_109_417 VDD VDD VSS VSS gf180mcu_fd_sc_mcu7t5v0__fill_2
X_3889_ _3889_/D _4162_/CLK _3889_/Q VDD VDD VSS VSS gf180mcu_fd_sc_mcu7t5v0__dffq_1
X_2909_ _3972_/Q _3914_/Q _3913_/Q _3971_/Q _2910_/B VDD VDD VSS VSS gf180mcu_fd_sc_mcu7t5v0__oai211_1
XFILLER_104_133 VDD VDD VSS VSS gf180mcu_fd_sc_mcu7t5v0__fill_2
XFILLER_104_177 VDD VDD VSS VSS gf180mcu_fd_sc_mcu7t5v0__fill_2
XTAP_TAPCELL_ROW_76_708 VDD VSS gf180mcu_fd_sc_mcu7t5v0__filltie
XFILLER_100_350 VDD VDD VSS VSS gf180mcu_fd_sc_mcu7t5v0__fill_1
XFILLER_100_394 VDD VDD VSS VSS gf180mcu_fd_sc_mcu7t5v0__fill_1
XTAP_TAPCELL_ROW_1_260 VDD VSS gf180mcu_fd_sc_mcu7t5v0__filltie
XFILLER_61_418 VDD VDD VSS VSS gf180mcu_fd_sc_mcu7t5v0__fill_2
XFILLER_41_120 VDD VDD VSS VSS gf180mcu_fd_sc_mcu7t5v0__fill_2
XFILLER_41_142 VDD VDD VSS VSS gf180mcu_fd_sc_mcu7t5v0__fillcap_4
XTAP_TAPCELL_ROW_24_395 VDD VSS gf180mcu_fd_sc_mcu7t5v0__filltie
XFILLER_41_72 VDD VDD VSS VSS gf180mcu_fd_sc_mcu7t5v0__fill_2
XFILLER_1_271 VDD VDD VSS VSS gf180mcu_fd_sc_mcu7t5v0__fill_2
XTAP_TAPCELL_ROW_119_967 VDD VSS gf180mcu_fd_sc_mcu7t5v0__filltie
XFILLER_2_66 VDD VDD VSS VSS gf180mcu_fd_sc_mcu7t5v0__fillcap_4
XFILLER_2_99 VDD VDD VSS VSS gf180mcu_fd_sc_mcu7t5v0__fill_2
XTAP_TAPCELL_ROW_15_340 VDD VSS gf180mcu_fd_sc_mcu7t5v0__filltie
X_3812_ _3812_/D clkload7/I _3812_/Q VDD VDD VSS VSS gf180mcu_fd_sc_mcu7t5v0__dffq_1
XPHY_EDGE_ROW_120_Right_120 VDD VSS gf180mcu_fd_sc_mcu7t5v0__endcap
XTAP_TAPCELL_ROW_102_867 VDD VSS gf180mcu_fd_sc_mcu7t5v0__filltie
X_3743_ wire90/Z _3746_/A2 _3746_/B _3744_/B VDD VDD VSS VSS gf180mcu_fd_sc_mcu7t5v0__oai21_1
XFILLER_118_247 VDD VDD VSS VSS gf180mcu_fd_sc_mcu7t5v0__fillcap_4
X_3674_ _3846_/Q _2104_/Z _3674_/B _3675_/A3 VDD VDD VSS VSS gf180mcu_fd_sc_mcu7t5v0__oai21_1
X_2625_ _2625_/A1 _2625_/A2 _3918_/Q _2700_/A1 VDD VDD VSS VSS gf180mcu_fd_sc_mcu7t5v0__aoi21_1
X_2556_ hold225/Z _2402_/B _3881_/D VDD VDD VSS VSS gf180mcu_fd_sc_mcu7t5v0__nor2_1
X_2487_ _2487_/A1 _2495_/A2 _2495_/B1 _2487_/B2 _2489_/A2 VDD VDD VSS VSS gf180mcu_fd_sc_mcu7t5v0__oai22_1
X_4157_ _4157_/D clkload9/I _4157_/Q VDD VDD VSS VSS gf180mcu_fd_sc_mcu7t5v0__dffq_1
XFILLER_28_404 VDD VDD VSS VSS gf180mcu_fd_sc_mcu7t5v0__fillcap_16
X_3108_ _3848_/Q _3108_/A2 _3256_/B _3109_/B VDD VDD VSS VSS gf180mcu_fd_sc_mcu7t5v0__oai21_1
X_4088_ _4088_/D clkload4/I _4088_/Q VDD VDD VSS VSS gf180mcu_fd_sc_mcu7t5v0__dffq_1
XFILLER_43_418 VDD VDD VSS VSS gf180mcu_fd_sc_mcu7t5v0__fill_2
XFILLER_55_278 VDD VDD VSS VSS gf180mcu_fd_sc_mcu7t5v0__fill_2
X_3039_ _4008_/Q _3224_/A1 _3207_/A1 _4000_/Q _3043_/A1 VDD VDD VSS VSS gf180mcu_fd_sc_mcu7t5v0__aoi22_1
XFILLER_102_45 VDD VDD VSS VSS gf180mcu_fd_sc_mcu7t5v0__fillcap_4
XFILLER_23_142 VDD VDD VSS VSS gf180mcu_fd_sc_mcu7t5v0__fillcap_32
XTAP_TAPCELL_ROW_21_376 VDD VSS gf180mcu_fd_sc_mcu7t5v0__filltie
XPHY_EDGE_ROW_12_Left_134 VDD VSS gf180mcu_fd_sc_mcu7t5v0__endcap
XFILLER_11_53 VDD VDD VSS VSS gf180mcu_fd_sc_mcu7t5v0__fill_2
XFILLER_120_423 VDD VDD VSS VSS gf180mcu_fd_sc_mcu7t5v0__fill_2
XPHY_EDGE_ROW_21_Left_143 VDD VSS gf180mcu_fd_sc_mcu7t5v0__endcap
XTAP_TAPCELL_ROW_116_948 VDD VSS gf180mcu_fd_sc_mcu7t5v0__filltie
XPHY_EDGE_ROW_30_Left_152 VDD VSS gf180mcu_fd_sc_mcu7t5v0__endcap
XFILLER_115_239 VDD VDD VSS VSS gf180mcu_fd_sc_mcu7t5v0__fillcap_4
X_2410_ _3849_/Q wire51/Z wire77/Z _3809_/Q _2411_/I VDD VDD VSS VSS gf180mcu_fd_sc_mcu7t5v0__aoi22_1
X_3390_ _4071_/Q _4070_/Q _4069_/Q _4068_/Q _3393_/A1 VDD VDD VSS VSS gf180mcu_fd_sc_mcu7t5v0__nor4_1
X_2341_ _3833_/Q _3834_/Q _2347_/B1 _2342_/B VDD VDD VSS VSS gf180mcu_fd_sc_mcu7t5v0__nand3_1
XFILLER_69_326 VDD VDD VSS VSS gf180mcu_fd_sc_mcu7t5v0__fill_1
X_2272_ _3256_/B _2272_/A2 _2362_/C VDD VDD VSS VSS gf180mcu_fd_sc_mcu7t5v0__nand2_1
X_4011_ _4011_/D clkload1/I _4011_/Q VDD VDD VSS VSS gf180mcu_fd_sc_mcu7t5v0__dffq_1
XTAP_TAPCELL_ROW_95_825 VDD VSS gf180mcu_fd_sc_mcu7t5v0__filltie
XFILLER_37_201 VDD VDD VSS VSS gf180mcu_fd_sc_mcu7t5v0__fillcap_4
XFILLER_92_340 VDD VDD VSS VSS gf180mcu_fd_sc_mcu7t5v0__fill_1
XFILLER_92_395 VDD VDD VSS VSS gf180mcu_fd_sc_mcu7t5v0__fill_2
XFILLER_20_123 VDD VDD VSS VSS gf180mcu_fd_sc_mcu7t5v0__fill_1
X_1987_ _3958_/Q _3121_/A1 VDD VDD VSS VSS gf180mcu_fd_sc_mcu7t5v0__clkinv_1
X_3726_ _3726_/A1 _3748_/A2 _3746_/A2 VDD VDD VSS VSS gf180mcu_fd_sc_mcu7t5v0__nand2_1
X_3657_ _4138_/Q _3700_/A1 _3679_/A1 _4130_/Q _3659_/A2 VDD VDD VSS VSS gf180mcu_fd_sc_mcu7t5v0__aoi22_1
X_3588_ _4123_/Q _4122_/Q _3588_/A3 _3650_/B1 VDD VDD VSS VSS gf180mcu_fd_sc_mcu7t5v0__nor3_1
X_2608_ _3211_/A1 _3910_/Q _2620_/A1 VDD VDD VSS VSS gf180mcu_fd_sc_mcu7t5v0__nor2_1
X_2539_ _3812_/Q _2542_/A3 _2541_/A2 VDD VDD VSS VSS gf180mcu_fd_sc_mcu7t5v0__nand2_1
XFILLER_87_156 VDD VDD VSS VSS gf180mcu_fd_sc_mcu7t5v0__fillcap_16
Xclkbuf_leaf_2__1473_ clkbuf_leaf_4__1473_/I _3498_/A2 VDD VDD VSS VSS gf180mcu_fd_sc_mcu7t5v0__clkbuf_8
XFILLER_28_234 VDD VDD VSS VSS gf180mcu_fd_sc_mcu7t5v0__fill_1
XFILLER_28_256 VDD VDD VSS VSS gf180mcu_fd_sc_mcu7t5v0__fillcap_4
XFILLER_113_66 VDD VDD VSS VSS gf180mcu_fd_sc_mcu7t5v0__fillcap_4
XFILLER_113_77 VDD VDD VSS VSS gf180mcu_fd_sc_mcu7t5v0__fill_2
XTAP_TAPCELL_ROW_113_929 VDD VSS gf180mcu_fd_sc_mcu7t5v0__filltie
Xwire71 wire71/I wire71/Z VDD VDD VSS VSS gf180mcu_fd_sc_mcu7t5v0__buf_2
XTAP_TAPCELL_ROW_121_984 VDD VSS gf180mcu_fd_sc_mcu7t5v0__filltie
XFILLER_11_134 VDD VDD VSS VSS gf180mcu_fd_sc_mcu7t5v0__fill_1
XFILLER_120_231 VDD VDD VSS VSS gf180mcu_fd_sc_mcu7t5v0__fillcap_8
XFILLER_19_212 VDD VDD VSS VSS gf180mcu_fd_sc_mcu7t5v0__fill_1
XFILLER_93_126 VDD VDD VSS VSS gf180mcu_fd_sc_mcu7t5v0__fillcap_4
XTAP_TAPCELL_ROW_49_549 VDD VSS gf180mcu_fd_sc_mcu7t5v0__filltie
XTAP_TAPCELL_ROW_92_806 VDD VSS gf180mcu_fd_sc_mcu7t5v0__filltie
XFILLER_34_226 VDD VDD VSS VSS gf180mcu_fd_sc_mcu7t5v0__fillcap_4
XFILLER_34_237 VDD VDD VSS VSS gf180mcu_fd_sc_mcu7t5v0__fillcap_4
XTAP_TAPCELL_ROW_57_593 VDD VSS gf180mcu_fd_sc_mcu7t5v0__filltie
X_2890_ _3969_/Q _3911_/Q _2890_/B _2891_/A2 VDD VDD VSS VSS gf180mcu_fd_sc_mcu7t5v0__aoi21_1
XFILLER_30_421 VDD VDD VSS VSS gf180mcu_fd_sc_mcu7t5v0__fillcap_4
X_1910_ _4035_/Q _3285_/A1 VDD VDD VSS VSS gf180mcu_fd_sc_mcu7t5v0__clkinv_1
XFILLER_8_65 VDD VDD VSS VSS gf180mcu_fd_sc_mcu7t5v0__fillcap_4
XTAP_TAPCELL_ROW_40_493 VDD VSS gf180mcu_fd_sc_mcu7t5v0__filltie
X_3511_ _4092_/Q _3508_/I _3511_/Z VDD VDD VSS VSS gf180mcu_fd_sc_mcu7t5v0__and2_1
X_3442_ _3442_/I _3443_/A2 VDD VDD VSS VSS gf180mcu_fd_sc_mcu7t5v0__clkinv_1
X_3373_ _4129_/Q _3385_/A2 _3373_/B _3384_/C VDD VDD VSS VSS gf180mcu_fd_sc_mcu7t5v0__oai21_1
X_2324_ _2339_/A1 _2323_/C _2328_/A2 VDD VDD VSS VSS gf180mcu_fd_sc_mcu7t5v0__nor2_1
X_2255_ _2252_/Z _2333_/B _2334_/B1 _2258_/B VDD VDD VSS VSS gf180mcu_fd_sc_mcu7t5v0__nand3_1
XFILLER_84_126 VDD VDD VSS VSS gf180mcu_fd_sc_mcu7t5v0__fill_2
XFILLER_84_137 VDD VDD VSS VSS gf180mcu_fd_sc_mcu7t5v0__fillcap_16
X_2186_ hold228/Z _2243_/A2 _3746_/B _2187_/A2 VDD VDD VSS VSS gf180mcu_fd_sc_mcu7t5v0__oai21_1
XFILLER_119_331 VDD VDD VSS VSS gf180mcu_fd_sc_mcu7t5v0__fillcap_4
X_3709_ _3709_/A1 _3717_/A2 _3709_/B _4135_/D VDD VDD VSS VSS gf180mcu_fd_sc_mcu7t5v0__aoi21_1
XFILLER_68_37 VDD VDD VSS VSS gf180mcu_fd_sc_mcu7t5v0__fillcap_4
XFILLER_102_264 VDD VDD VSS VSS gf180mcu_fd_sc_mcu7t5v0__fill_2
XFILLER_84_69 VDD VDD VSS VSS gf180mcu_fd_sc_mcu7t5v0__fillcap_4
XFILLER_90_107 VDD VDD VSS VSS gf180mcu_fd_sc_mcu7t5v0__fillcap_4
XFILLER_16_226 VDD VDD VSS VSS gf180mcu_fd_sc_mcu7t5v0__fill_1
XFILLER_31_207 VDD VDD VSS VSS gf180mcu_fd_sc_mcu7t5v0__fill_2
XTAP_TAPCELL_ROW_54_574 VDD VSS gf180mcu_fd_sc_mcu7t5v0__filltie
XFILLER_8_425 VDD VDD VSS VSS gf180mcu_fd_sc_mcu7t5v0__fill_1
XFILLER_58_70 VDD VDD VSS VSS gf180mcu_fd_sc_mcu7t5v0__fillcap_16
X_2040_ _3872_/Q _2525_/A1 VDD VDD VSS VSS gf180mcu_fd_sc_mcu7t5v0__clkinv_1
X_3991_ _3991_/D _4166_/CLK _3991_/Q VDD VDD VSS VSS gf180mcu_fd_sc_mcu7t5v0__dffq_1
XFILLER_22_229 VDD VDD VSS VSS gf180mcu_fd_sc_mcu7t5v0__fill_2
X_2942_ _2957_/A1 _3597_/A2 _3005_/A2 VDD VDD VSS VSS gf180mcu_fd_sc_mcu7t5v0__nor2_1
XFILLER_88_2 VDD VDD VSS VSS gf180mcu_fd_sc_mcu7t5v0__fill_2
X_2873_ _3143_/A1 _2873_/A2 _2885_/A1 VDD VDD VSS VSS gf180mcu_fd_sc_mcu7t5v0__nand2_1
X_3425_ _4074_/Q _3423_/Z _3439_/B _3426_/B VDD VDD VSS VSS gf180mcu_fd_sc_mcu7t5v0__oai21_1
X_3356_ _4059_/Q _3354_/Z _3363_/B _3357_/B VDD VDD VSS VSS gf180mcu_fd_sc_mcu7t5v0__aoi21_1
XFILLER_97_240 VDD VDD VSS VSS gf180mcu_fd_sc_mcu7t5v0__fill_2
X_2307_ _3813_/Q _2300_/S _2308_/B VDD VDD VSS VSS gf180mcu_fd_sc_mcu7t5v0__nor2_1
X_3287_ _3287_/A1 _3291_/A2 _3287_/B _4036_/D VDD VDD VSS VSS gf180mcu_fd_sc_mcu7t5v0__aoi21_1
X_2238_ _3453_/A1 _2111_/Z _2238_/B _3801_/D VDD VDD VSS VSS gf180mcu_fd_sc_mcu7t5v0__aoi21_1
XFILLER_57_137 VDD VDD VSS VSS gf180mcu_fd_sc_mcu7t5v0__fill_2
XFILLER_72_107 VDD VDD VSS VSS gf180mcu_fd_sc_mcu7t5v0__fill_1
X_2169_ _2169_/A1 _2169_/A2 hold197/I VDD VDD VSS VSS gf180mcu_fd_sc_mcu7t5v0__nor2_1
XFILLER_13_207 VDD VDD VSS VSS gf180mcu_fd_sc_mcu7t5v0__fill_2
XFILLER_80_162 VDD VDD VSS VSS gf180mcu_fd_sc_mcu7t5v0__fillcap_4
XFILLER_119_65 VDD VDD VSS VSS gf180mcu_fd_sc_mcu7t5v0__fillcap_4
XTAP_TAPCELL_ROW_8_299 VDD VSS gf180mcu_fd_sc_mcu7t5v0__filltie
XFILLER_56_181 VDD VDD VSS VSS gf180mcu_fd_sc_mcu7t5v0__fill_1
XFILLER_63_129 VDD VDD VSS VSS gf180mcu_fd_sc_mcu7t5v0__fillcap_8
XFILLER_44_387 VDD VDD VSS VSS gf180mcu_fd_sc_mcu7t5v0__fill_1
XPHY_EDGE_ROW_4_Left_126 VDD VSS gf180mcu_fd_sc_mcu7t5v0__endcap
XFILLER_8_233 VDD VDD VSS VSS gf180mcu_fd_sc_mcu7t5v0__fillcap_8
XFILLER_5_11 VDD VDD VSS VSS gf180mcu_fd_sc_mcu7t5v0__fillcap_8
XFILLER_60_93 VDD VDD VSS VSS gf180mcu_fd_sc_mcu7t5v0__fill_1
XFILLER_79_251 VDD VDD VSS VSS gf180mcu_fd_sc_mcu7t5v0__fillcap_8
X_3210_ _3750_/I1 _3217_/A2 wire81/Z _3211_/B VDD VDD VSS VSS gf180mcu_fd_sc_mcu7t5v0__oai21_1
X_3141_ _3141_/A1 _3151_/A2 _3141_/B _3967_/D VDD VDD VSS VSS gf180mcu_fd_sc_mcu7t5v0__aoi21_1
X_3072_ _3072_/A1 _3080_/A2 _3072_/B _3935_/D VDD VDD VSS VSS gf180mcu_fd_sc_mcu7t5v0__aoi21_1
XFILLER_35_321 VDD VDD VSS VSS gf180mcu_fd_sc_mcu7t5v0__fill_2
X_2023_ _3807_/Q _2457_/A1 VDD VDD VSS VSS gf180mcu_fd_sc_mcu7t5v0__clkinv_1
X_3974_ _3974_/D _4166_/CLK _3974_/Q VDD VDD VSS VSS gf180mcu_fd_sc_mcu7t5v0__dffq_1
XTAP_TAPCELL_ROW_73_691 VDD VSS gf180mcu_fd_sc_mcu7t5v0__filltie
X_2925_ _2926_/B _2926_/A1 _2924_/Z _2925_/Z VDD VDD VSS VSS gf180mcu_fd_sc_mcu7t5v0__and3_1
X_2856_ _3138_/A1 _2856_/A2 _2864_/C VDD VDD VSS VSS gf180mcu_fd_sc_mcu7t5v0__nor2_1
Xhold200 _4050_/Q hold200/Z VDD VDD VSS VSS gf180mcu_fd_sc_mcu7t5v0__dlyc_1
X_2787_ _3957_/Q _3899_/Q _2791_/B VDD VDD VSS VSS gf180mcu_fd_sc_mcu7t5v0__xnor2_1
Xhold211 _4099_/Q _1891_/I VDD VDD VSS VSS gf180mcu_fd_sc_mcu7t5v0__dlyc_1
Xhold233 _4050_/Q hold233/Z VDD VDD VSS VSS gf180mcu_fd_sc_mcu7t5v0__dlyc_1
Xhold222 _4051_/Q hold222/Z VDD VDD VSS VSS gf180mcu_fd_sc_mcu7t5v0__dlyc_1
X_3408_ _4067_/Q _3404_/Z _3408_/B _4067_/D VDD VDD VSS VSS gf180mcu_fd_sc_mcu7t5v0__aoi21_1
XFILLER_49_39 VDD VDD VSS VSS gf180mcu_fd_sc_mcu7t5v0__fill_2
X_3339_ _4053_/Q _4052_/Q _4051_/Q _3330_/Z _3339_/Z VDD VDD VSS VSS gf180mcu_fd_sc_mcu7t5v0__and4_1
XFILLER_85_265 VDD VDD VSS VSS gf180mcu_fd_sc_mcu7t5v0__fill_1
XFILLER_105_78 VDD VDD VSS VSS gf180mcu_fd_sc_mcu7t5v0__fill_1
XFILLER_26_321 VDD VDD VSS VSS gf180mcu_fd_sc_mcu7t5v0__fill_2
XFILLER_121_33 VDD VDD VSS VSS gf180mcu_fd_sc_mcu7t5v0__fill_1
XFILLER_26_387 VDD VDD VSS VSS gf180mcu_fd_sc_mcu7t5v0__fillcap_32
XPHY_EDGE_ROW_77_Left_199 VDD VSS gf180mcu_fd_sc_mcu7t5v0__endcap
XFILLER_81_59 VDD VDD VSS VSS gf180mcu_fd_sc_mcu7t5v0__fillcap_8
XFILLER_107_131 VDD VDD VSS VSS gf180mcu_fd_sc_mcu7t5v0__fill_2
XFILLER_107_142 VDD VDD VSS VSS gf180mcu_fd_sc_mcu7t5v0__fill_2
XFILLER_107_197 VDD VDD VSS VSS gf180mcu_fd_sc_mcu7t5v0__fillcap_8
XTAP_TAPCELL_ROW_79_728 VDD VSS gf180mcu_fd_sc_mcu7t5v0__filltie
XFILLER_39_72 VDD VDD VSS VSS gf180mcu_fd_sc_mcu7t5v0__fillcap_8
XFILLER_103_381 VDD VDD VSS VSS gf180mcu_fd_sc_mcu7t5v0__fillcap_4
XFILLER_36_107 VDD VDD VSS VSS gf180mcu_fd_sc_mcu7t5v0__fillcap_32
XFILLER_76_254 VDD VDD VSS VSS gf180mcu_fd_sc_mcu7t5v0__fill_2
XTAP_TAPCELL_ROW_87_772 VDD VSS gf180mcu_fd_sc_mcu7t5v0__filltie
XFILLER_17_310 VDD VDD VSS VSS gf180mcu_fd_sc_mcu7t5v0__fillcap_16
XPHY_EDGE_ROW_101_Right_101 VDD VSS gf180mcu_fd_sc_mcu7t5v0__endcap
XFILLER_91_246 VDD VDD VSS VSS gf180mcu_fd_sc_mcu7t5v0__fillcap_4
XTAP_TAPCELL_ROW_70_672 VDD VSS gf180mcu_fd_sc_mcu7t5v0__filltie
X_2710_ _2710_/A1 _2710_/A2 _2710_/B _2720_/B2 VDD VDD VSS VSS gf180mcu_fd_sc_mcu7t5v0__oai21_1
X_3690_ _4128_/Q _3678_/Z _3746_/B _3691_/A2 VDD VDD VSS VSS gf180mcu_fd_sc_mcu7t5v0__oai21_1
X_2641_ _3253_/A1 _3898_/Q _3897_/Q _3251_/A1 _2646_/A1 VDD VDD VSS VSS gf180mcu_fd_sc_mcu7t5v0__aoi22_1
X_2572_ _3976_/Q _2706_/A2 _2575_/A2 VDD VDD VSS VSS gf180mcu_fd_sc_mcu7t5v0__nor2_1
XFILLER_113_156 VDD VDD VSS VSS gf180mcu_fd_sc_mcu7t5v0__fill_2
X_3124_ _3124_/A1 _3138_/A2 _3124_/B _3959_/D VDD VDD VSS VSS gf180mcu_fd_sc_mcu7t5v0__aoi21_1
Xclkbuf_leaf_18_ext_clk_in clkbuf_leaf_1_ext_clk_in/I _4021_/CLK VDD VDD VSS VSS gf180mcu_fd_sc_mcu7t5v0__clkbuf_8
XFILLER_67_254 VDD VDD VSS VSS gf180mcu_fd_sc_mcu7t5v0__fill_1
XFILLER_67_276 VDD VDD VSS VSS gf180mcu_fd_sc_mcu7t5v0__fillcap_4
X_3055_ _3928_/Q _3676_/A2 _3055_/B1 _3055_/B2 _3056_/A2 VDD VDD VSS VSS gf180mcu_fd_sc_mcu7t5v0__aoi22_1
X_2006_ _2006_/I _3080_/A1 VDD VDD VSS VSS gf180mcu_fd_sc_mcu7t5v0__clkinv_1
XTAP_TAPCELL_ROW_18_360 VDD VSS gf180mcu_fd_sc_mcu7t5v0__filltie
XFILLER_23_335 VDD VDD VSS VSS gf180mcu_fd_sc_mcu7t5v0__fillcap_8
X_3957_ _3957_/D clkload9/I _3957_/Q VDD VDD VSS VSS gf180mcu_fd_sc_mcu7t5v0__dffq_1
XFILLER_51_18 VDD VDD VSS VSS gf180mcu_fd_sc_mcu7t5v0__fillcap_16
X_2908_ _2908_/A1 _2899_/Z _2902_/Z _2922_/A1 VDD VDD VSS VSS gf180mcu_fd_sc_mcu7t5v0__nor3_1
X_3888_ _3888_/D _4162_/CLK _3888_/Q VDD VDD VSS VSS gf180mcu_fd_sc_mcu7t5v0__dffq_1
X_2839_ _2831_/Z _2839_/A2 _2840_/A2 VDD VDD VSS VSS gf180mcu_fd_sc_mcu7t5v0__xnor2_1
XFILLER_2_206 VDD VDD VSS VSS gf180mcu_fd_sc_mcu7t5v0__fillcap_8
XFILLER_58_232 VDD VDD VSS VSS gf180mcu_fd_sc_mcu7t5v0__fillcap_4
XTAP_TAPCELL_ROW_76_709 VDD VSS gf180mcu_fd_sc_mcu7t5v0__filltie
XFILLER_58_287 VDD VDD VSS VSS gf180mcu_fd_sc_mcu7t5v0__fill_2
XPHY_EDGE_ROW_85_Left_207 VDD VSS gf180mcu_fd_sc_mcu7t5v0__endcap
XFILLER_100_384 VDD VDD VSS VSS gf180mcu_fd_sc_mcu7t5v0__fill_1
XFILLER_26_140 VDD VDD VSS VSS gf180mcu_fd_sc_mcu7t5v0__fillcap_4
XTAP_TAPCELL_ROW_1_261 VDD VSS gf180mcu_fd_sc_mcu7t5v0__filltie
XTAP_TAPCELL_ROW_24_396 VDD VSS gf180mcu_fd_sc_mcu7t5v0__filltie
XPHY_EDGE_ROW_94_Left_216 VDD VSS gf180mcu_fd_sc_mcu7t5v0__endcap
XFILLER_49_232 VDD VDD VSS VSS gf180mcu_fd_sc_mcu7t5v0__fillcap_8
XFILLER_110_159 VDD VDD VSS VSS gf180mcu_fd_sc_mcu7t5v0__fillcap_16
XFILLER_49_254 VDD VDD VSS VSS gf180mcu_fd_sc_mcu7t5v0__fillcap_8
XTAP_TAPCELL_ROW_119_968 VDD VSS gf180mcu_fd_sc_mcu7t5v0__filltie
XFILLER_37_416 VDD VDD VSS VSS gf180mcu_fd_sc_mcu7t5v0__fillcap_4
XFILLER_64_279 VDD VDD VSS VSS gf180mcu_fd_sc_mcu7t5v0__fillcap_8
XFILLER_17_195 VDD VDD VSS VSS gf180mcu_fd_sc_mcu7t5v0__fill_1
XTAP_TAPCELL_ROW_15_341 VDD VSS gf180mcu_fd_sc_mcu7t5v0__filltie
X_3811_ _3811_/D clkload7/I _3811_/Q VDD VDD VSS VSS gf180mcu_fd_sc_mcu7t5v0__dffq_1
X_3742_ _3742_/A1 _3742_/A2 _4145_/D VDD VDD VSS VSS gf180mcu_fd_sc_mcu7t5v0__nor2_1
X_3673_ _3731_/C _3673_/A2 _4122_/D VDD VDD VSS VSS gf180mcu_fd_sc_mcu7t5v0__nor2_1
X_2624_ _2625_/A1 _2625_/A2 _2928_/A2 VDD VDD VSS VSS gf180mcu_fd_sc_mcu7t5v0__nand2_1
X_2555_ _4157_/Q _2555_/A2 _2555_/A3 _2555_/B1 _2554_/I _3880_/D VDD VDD VSS VSS gf180mcu_fd_sc_mcu7t5v0__oai32_1
X_2486_ _2486_/I0 hold190/Z _2489_/C _3867_/D VDD VDD VSS VSS gf180mcu_fd_sc_mcu7t5v0__mux2_2
X_4156_ _4156_/D _4162_/CLK _4156_/Q VDD VDD VSS VSS gf180mcu_fd_sc_mcu7t5v0__dffq_1
X_3107_ _3107_/A1 _3121_/A2 _3107_/B _3951_/D VDD VDD VSS VSS gf180mcu_fd_sc_mcu7t5v0__aoi21_1
X_4087_ _4087_/D clkload4/I _4087_/Q VDD VDD VSS VSS gf180mcu_fd_sc_mcu7t5v0__dffq_1
X_3038_ _3038_/I _3044_/B VDD VDD VSS VSS gf180mcu_fd_sc_mcu7t5v0__clkinv_1
XFILLER_102_68 VDD VDD VSS VSS gf180mcu_fd_sc_mcu7t5v0__fill_1
XTAP_TAPCELL_ROW_21_377 VDD VSS gf180mcu_fd_sc_mcu7t5v0__filltie
XTAP_TAPCELL_ROW_116_949 VDD VSS gf180mcu_fd_sc_mcu7t5v0__filltie
XFILLER_34_419 VDD VDD VSS VSS gf180mcu_fd_sc_mcu7t5v0__fillcap_4
XTAP_TAPCELL_ROW_12_322 VDD VSS gf180mcu_fd_sc_mcu7t5v0__filltie
XFILLER_52_94 VDD VDD VSS VSS gf180mcu_fd_sc_mcu7t5v0__fill_2
XFILLER_10_382 VDD VDD VSS VSS gf180mcu_fd_sc_mcu7t5v0__fill_2
X_2340_ _4163_/Q _2360_/A2 _2347_/B1 VDD VDD VSS VSS gf180mcu_fd_sc_mcu7t5v0__nand2_1
XFILLER_96_102 VDD VDD VSS VSS gf180mcu_fd_sc_mcu7t5v0__fill_2
X_2271_ _2271_/A1 _2271_/A2 _2270_/Z _3823_/Q _2289_/A2 VDD VDD VSS VSS gf180mcu_fd_sc_mcu7t5v0__oai22_1
X_4010_ _4010_/D clkload1/I _4010_/Q VDD VDD VSS VSS gf180mcu_fd_sc_mcu7t5v0__dffq_1
X_1986_ _3959_/Q _3124_/A1 VDD VDD VSS VSS gf180mcu_fd_sc_mcu7t5v0__clkinv_1
X_3725_ _3726_/A1 _3748_/A2 _3725_/Z VDD VDD VSS VSS gf180mcu_fd_sc_mcu7t5v0__and2_1
X_3656_ _3667_/C2 _3656_/A2 _3659_/A1 VDD VDD VSS VSS gf180mcu_fd_sc_mcu7t5v0__nand2_1
X_3587_ _3674_/B _3720_/A3 _3587_/B _3588_/A3 VDD VDD VSS VSS gf180mcu_fd_sc_mcu7t5v0__oai21_1
X_2607_ _4004_/Q _2910_/A2 _2607_/B _2607_/C _2619_/B VDD VDD VSS VSS gf180mcu_fd_sc_mcu7t5v0__aoi211_1
XFILLER_114_251 VDD VDD VSS VSS gf180mcu_fd_sc_mcu7t5v0__fill_2
XFILLER_114_262 VDD VDD VSS VSS gf180mcu_fd_sc_mcu7t5v0__fill_2
XFILLER_114_240 VDD VDD VSS VSS gf180mcu_fd_sc_mcu7t5v0__fillcap_4
X_2538_ _2538_/A1 _2542_/A3 _2538_/B _2543_/B1 VDD VDD VSS VSS gf180mcu_fd_sc_mcu7t5v0__aoi21_1
Xclkbuf_leaf_8_ext_clk_in clkload0/I _4164_/CLK VDD VDD VSS VSS gf180mcu_fd_sc_mcu7t5v0__clkbuf_8
XFILLER_114_273 VDD VDD VSS VSS gf180mcu_fd_sc_mcu7t5v0__fillcap_32
XFILLER_87_113 VDD VDD VSS VSS gf180mcu_fd_sc_mcu7t5v0__fill_2
X_2469_ _2495_/C _2469_/A2 _2466_/Z _2496_/B _2489_/C _2470_/B VDD VDD VSS VSS gf180mcu_fd_sc_mcu7t5v0__aoi221_1
XFILLER_87_146 VDD VDD VSS VSS gf180mcu_fd_sc_mcu7t5v0__fill_1
X_4139_ _4139_/D _4155_/CLK _4139_/Q VDD VDD VSS VSS gf180mcu_fd_sc_mcu7t5v0__dffq_1
XFILLER_16_419 VDD VDD VSS VSS gf180mcu_fd_sc_mcu7t5v0__fillcap_4
XFILLER_83_385 VDD VDD VSS VSS gf180mcu_fd_sc_mcu7t5v0__fill_1
Xwire94 wire94/I wire94/Z VDD VDD VSS VSS gf180mcu_fd_sc_mcu7t5v0__buf_4
XTAP_TAPCELL_ROW_121_985 VDD VSS gf180mcu_fd_sc_mcu7t5v0__filltie
XFILLER_7_139 VDD VDD VSS VSS gf180mcu_fd_sc_mcu7t5v0__fill_1
XFILLER_0_2 VDD VDD VSS VSS gf180mcu_fd_sc_mcu7t5v0__fillcap_32
XFILLER_120_243 VDD VDD VSS VSS gf180mcu_fd_sc_mcu7t5v0__fill_2
XTAP_TAPCELL_ROW_92_807 VDD VSS gf180mcu_fd_sc_mcu7t5v0__filltie
XFILLER_19_279 VDD VDD VSS VSS gf180mcu_fd_sc_mcu7t5v0__fill_1
XTAP_TAPCELL_ROW_57_594 VDD VSS gf180mcu_fd_sc_mcu7t5v0__filltie
XFILLER_63_93 VDD VDD VSS VSS gf180mcu_fd_sc_mcu7t5v0__fillcap_4
XFILLER_8_55 VDD VDD VSS VSS gf180mcu_fd_sc_mcu7t5v0__fillcap_4
X_3510_ _3510_/A1 _3510_/A2 _3510_/B _3552_/C _4091_/D VDD VDD VSS VSS gf180mcu_fd_sc_mcu7t5v0__aoi211_1
XTAP_TAPCELL_ROW_40_494 VDD VSS gf180mcu_fd_sc_mcu7t5v0__filltie
X_3441_ _4081_/Q _4080_/Q _4083_/Q _4082_/Q _3442_/I VDD VDD VSS VSS gf180mcu_fd_sc_mcu7t5v0__oai211_1
X_3372_ _4132_/Q _3392_/A1 _4064_/Q _3681_/A1 _3372_/C _3386_/A2 VDD VDD VSS VSS gf180mcu_fd_sc_mcu7t5v0__aoi221_1
X_2323_ _4159_/Q _2252_/Z _2362_/C _2323_/C _2325_/S VDD VDD VSS VSS gf180mcu_fd_sc_mcu7t5v0__aoi211_1
XFILLER_69_135 VDD VDD VSS VSS gf180mcu_fd_sc_mcu7t5v0__fillcap_4
XFILLER_97_422 VDD VDD VSS VSS gf180mcu_fd_sc_mcu7t5v0__fillcap_4
X_2254_ _2363_/A2 _3825_/Q _2334_/B1 VDD VDD VSS VSS gf180mcu_fd_sc_mcu7t5v0__nand2_1
XFILLER_69_179 VDD VDD VSS VSS gf180mcu_fd_sc_mcu7t5v0__fillcap_4
X_2185_ _4080_/Q _2242_/A2 _2187_/A1 VDD VDD VSS VSS gf180mcu_fd_sc_mcu7t5v0__nor2_1
XFILLER_80_377 VDD VDD VSS VSS gf180mcu_fd_sc_mcu7t5v0__fill_2
XFILLER_21_422 VDD VDD VSS VSS gf180mcu_fd_sc_mcu7t5v0__fillcap_4
XFILLER_33_282 VDD VDD VSS VSS gf180mcu_fd_sc_mcu7t5v0__fill_2
X_1969_ _1969_/I _3160_/A1 VDD VDD VSS VSS gf180mcu_fd_sc_mcu7t5v0__clkinv_1
X_3708_ wire91/Z _3717_/A2 wire81/Z _3709_/B VDD VDD VSS VSS gf180mcu_fd_sc_mcu7t5v0__oai21_1
XFILLER_4_109 VDD VDD VSS VSS gf180mcu_fd_sc_mcu7t5v0__fill_1
X_3639_ _3846_/Q _3639_/A2 _3639_/B _3639_/C _3640_/B2 VDD VDD VSS VSS gf180mcu_fd_sc_mcu7t5v0__oai211_1
XFILLER_108_45 VDD VDD VSS VSS gf180mcu_fd_sc_mcu7t5v0__fill_2
XFILLER_102_276 VDD VDD VSS VSS gf180mcu_fd_sc_mcu7t5v0__fill_1
XFILLER_84_37 VDD VDD VSS VSS gf180mcu_fd_sc_mcu7t5v0__fill_1
XFILLER_17_31 VDD VDD VSS VSS gf180mcu_fd_sc_mcu7t5v0__fillcap_4
XTAP_TAPCELL_ROW_54_575 VDD VSS gf180mcu_fd_sc_mcu7t5v0__filltie
XFILLER_33_63 VDD VDD VSS VSS gf180mcu_fd_sc_mcu7t5v0__fill_2
XFILLER_3_142 VDD VDD VSS VSS gf180mcu_fd_sc_mcu7t5v0__fill_2
XFILLER_94_425 VDD VDD VSS VSS gf180mcu_fd_sc_mcu7t5v0__fill_1
XFILLER_47_352 VDD VDD VSS VSS gf180mcu_fd_sc_mcu7t5v0__fillcap_4
XFILLER_62_300 VDD VDD VSS VSS gf180mcu_fd_sc_mcu7t5v0__fillcap_4
XTAP_TAPCELL_ROW_45_520 VDD VSS gf180mcu_fd_sc_mcu7t5v0__filltie
X_3990_ _3990_/D clkload2/I _3990_/Q VDD VDD VSS VSS gf180mcu_fd_sc_mcu7t5v0__dffq_1
X_2941_ _3838_/Q _3837_/Q _3597_/A2 VDD VDD VSS VSS gf180mcu_fd_sc_mcu7t5v0__nand2_1
XFILLER_62_377 VDD VDD VSS VSS gf180mcu_fd_sc_mcu7t5v0__fill_2
XFILLER_15_282 VDD VDD VSS VSS gf180mcu_fd_sc_mcu7t5v0__fillcap_16
X_2872_ _3968_/Q _3910_/Q _2884_/C VDD VDD VSS VSS gf180mcu_fd_sc_mcu7t5v0__nor2_1
XFILLER_30_263 VDD VDD VSS VSS gf180mcu_fd_sc_mcu7t5v0__fillcap_8
XFILLER_90_80 VDD VDD VSS VSS gf180mcu_fd_sc_mcu7t5v0__fillcap_8
Xclkbuf_1_0__f__1477_ clkbuf_0__1477_/Z _3536_/A2 VDD VDD VSS VSS gf180mcu_fd_sc_mcu7t5v0__clkbuf_16
X_3424_ _3401_/I _3424_/A2 _3423_/Z _4073_/D VDD VDD VSS VSS gf180mcu_fd_sc_mcu7t5v0__nor3_1
XPHY_EDGE_ROW_115_Right_115 VDD VSS gf180mcu_fd_sc_mcu7t5v0__endcap
X_3355_ _3363_/B _3355_/A2 _3354_/Z _4058_/D VDD VDD VSS VSS gf180mcu_fd_sc_mcu7t5v0__nor3_1
X_2306_ _2487_/A1 _2300_/S _2306_/B _3813_/D VDD VDD VSS VSS gf180mcu_fd_sc_mcu7t5v0__oai21_1
X_3286_ _3286_/A1 _3291_/A2 wire81/Z _3287_/B VDD VDD VSS VSS gf180mcu_fd_sc_mcu7t5v0__oai21_1
X_2237_ _3801_/Q _2111_/Z _3746_/B _2238_/B VDD VDD VSS VSS gf180mcu_fd_sc_mcu7t5v0__oai21_1
X_2168_ hold196/Z _2243_/A2 _3746_/B _2169_/A2 VDD VDD VSS VSS gf180mcu_fd_sc_mcu7t5v0__oai21_1
X_2099_ _3844_/Q _3843_/Q _3842_/Q _3053_/A2 wire79/I VDD VDD VSS VSS gf180mcu_fd_sc_mcu7t5v0__nor4_1
XFILLER_80_174 VDD VDD VSS VSS gf180mcu_fd_sc_mcu7t5v0__fill_1
XTAP_TAPCELL_ROW_51_556 VDD VSS gf180mcu_fd_sc_mcu7t5v0__filltie
XPHY_EDGE_ROW_17_Right_17 VDD VSS gf180mcu_fd_sc_mcu7t5v0__endcap
XFILLER_107_324 VDD VDD VSS VSS gf180mcu_fd_sc_mcu7t5v0__fill_1
XPHY_EDGE_ROW_26_Right_26 VDD VSS gf180mcu_fd_sc_mcu7t5v0__endcap
XFILLER_95_36 VDD VDD VSS VSS gf180mcu_fd_sc_mcu7t5v0__fillcap_4
XFILLER_95_69 VDD VDD VSS VSS gf180mcu_fd_sc_mcu7t5v0__fill_1
XFILLER_28_63 VDD VDD VSS VSS gf180mcu_fd_sc_mcu7t5v0__fillcap_4
XFILLER_91_417 VDD VDD VSS VSS gf180mcu_fd_sc_mcu7t5v0__fill_2
XPHY_EDGE_ROW_35_Right_35 VDD VSS gf180mcu_fd_sc_mcu7t5v0__endcap
XPHY_EDGE_ROW_44_Right_44 VDD VSS gf180mcu_fd_sc_mcu7t5v0__endcap
X_3140_ wire94/Z _3151_/A2 wire81/Z _3141_/B VDD VDD VSS VSS gf180mcu_fd_sc_mcu7t5v0__oai21_1
XFILLER_79_274 VDD VDD VSS VSS gf180mcu_fd_sc_mcu7t5v0__fill_2
XFILLER_79_263 VDD VDD VSS VSS gf180mcu_fd_sc_mcu7t5v0__fill_2
XPHY_EDGE_ROW_105_Left_227 VDD VSS gf180mcu_fd_sc_mcu7t5v0__endcap
XFILLER_39_138 VDD VDD VSS VSS gf180mcu_fd_sc_mcu7t5v0__fill_2
X_3071_ wire91/Z _3080_/A2 wire81/Z _3072_/B VDD VDD VSS VSS gf180mcu_fd_sc_mcu7t5v0__oai21_1
XFILLER_94_255 VDD VDD VSS VSS gf180mcu_fd_sc_mcu7t5v0__fillcap_8
X_2022_ _3855_/Q _2457_/B2 VDD VDD VSS VSS gf180mcu_fd_sc_mcu7t5v0__clkinv_1
XFILLER_62_141 VDD VDD VSS VSS gf180mcu_fd_sc_mcu7t5v0__fill_1
XFILLER_50_314 VDD VDD VSS VSS gf180mcu_fd_sc_mcu7t5v0__fill_1
XPHY_EDGE_ROW_114_Left_236 VDD VSS gf180mcu_fd_sc_mcu7t5v0__endcap
XPHY_EDGE_ROW_53_Right_53 VDD VSS gf180mcu_fd_sc_mcu7t5v0__endcap
X_3973_ _3973_/D _4166_/CLK _3973_/Q VDD VDD VSS VSS gf180mcu_fd_sc_mcu7t5v0__dffq_1
XTAP_TAPCELL_ROW_73_692 VDD VSS gf180mcu_fd_sc_mcu7t5v0__filltie
X_2924_ _2924_/A1 _2924_/A2 _2924_/Z VDD VDD VSS VSS gf180mcu_fd_sc_mcu7t5v0__and2_1
X_2855_ _3138_/A1 _2856_/A2 _2864_/A2 VDD VDD VSS VSS gf180mcu_fd_sc_mcu7t5v0__nand2_1
Xclkbuf_1_0__f__1529_ clkbuf_0__1529_/Z _3534_/B VDD VDD VSS VSS gf180mcu_fd_sc_mcu7t5v0__clkbuf_16
XFILLER_116_121 VDD VDD VSS VSS gf180mcu_fd_sc_mcu7t5v0__fill_2
X_2786_ _2760_/C _2785_/Z _3898_/D VDD VDD VSS VSS gf180mcu_fd_sc_mcu7t5v0__nor2_1
Xhold201 hold201/I _3769_/D VDD VDD VSS VSS gf180mcu_fd_sc_mcu7t5v0__dlyc_1
Xhold223 _3825_/Q hold223/Z VDD VDD VSS VSS gf180mcu_fd_sc_mcu7t5v0__dlyc_1
Xhold234 _4062_/Q hold234/Z VDD VDD VSS VSS gf180mcu_fd_sc_mcu7t5v0__dlyc_1
Xhold212 _3999_/Q _1946_/I VDD VDD VSS VSS gf180mcu_fd_sc_mcu7t5v0__dlyc_1
XPHY_EDGE_ROW_62_Right_62 VDD VSS gf180mcu_fd_sc_mcu7t5v0__endcap
X_3407_ _4067_/Q _3404_/Z _3439_/B _3408_/B VDD VDD VSS VSS gf180mcu_fd_sc_mcu7t5v0__oai21_1
X_3338_ hold235/Z _3336_/Z _3340_/A2 VDD VDD VSS VSS gf180mcu_fd_sc_mcu7t5v0__nor2_1
XFILLER_85_222 VDD VDD VSS VSS gf180mcu_fd_sc_mcu7t5v0__fillcap_4
X_3269_ _3754_/I1 _3274_/A2 wire81/Z _3270_/B VDD VDD VSS VSS gf180mcu_fd_sc_mcu7t5v0__oai21_1
XFILLER_105_68 VDD VDD VSS VSS gf180mcu_fd_sc_mcu7t5v0__fill_2
XFILLER_38_171 VDD VDD VSS VSS gf180mcu_fd_sc_mcu7t5v0__fillcap_4
XFILLER_85_288 VDD VDD VSS VSS gf180mcu_fd_sc_mcu7t5v0__fillcap_4
XFILLER_121_78 VDD VDD VSS VSS gf180mcu_fd_sc_mcu7t5v0__fillcap_4
XPHY_EDGE_ROW_71_Right_71 VDD VSS gf180mcu_fd_sc_mcu7t5v0__endcap
XFILLER_81_16 VDD VDD VSS VSS gf180mcu_fd_sc_mcu7t5v0__fill_2
XFILLER_41_358 VDD VDD VSS VSS gf180mcu_fd_sc_mcu7t5v0__fill_1
XFILLER_53_196 VDD VDD VSS VSS gf180mcu_fd_sc_mcu7t5v0__fill_2
XFILLER_14_32 VDD VDD VSS VSS gf180mcu_fd_sc_mcu7t5v0__fill_2
XFILLER_30_31 VDD VDD VSS VSS gf180mcu_fd_sc_mcu7t5v0__fillcap_4
XPHY_EDGE_ROW_80_Right_80 VDD VSS gf180mcu_fd_sc_mcu7t5v0__endcap
XFILLER_107_154 VDD VDD VSS VSS gf180mcu_fd_sc_mcu7t5v0__fill_1
XFILLER_110_319 VDD VDD VSS VSS gf180mcu_fd_sc_mcu7t5v0__fill_1
XFILLER_39_40 VDD VDD VSS VSS gf180mcu_fd_sc_mcu7t5v0__fill_2
XTAP_TAPCELL_ROW_79_729 VDD VSS gf180mcu_fd_sc_mcu7t5v0__filltie
XTAP_TAPCELL_ROW_87_773 VDD VSS gf180mcu_fd_sc_mcu7t5v0__filltie
XFILLER_55_72 VDD VDD VSS VSS gf180mcu_fd_sc_mcu7t5v0__fillcap_4
XFILLER_32_303 VDD VDD VSS VSS gf180mcu_fd_sc_mcu7t5v0__fillcap_4
XTAP_TAPCELL_ROW_70_673 VDD VSS gf180mcu_fd_sc_mcu7t5v0__filltie
XFILLER_118_419 VDD VDD VSS VSS gf180mcu_fd_sc_mcu7t5v0__fillcap_4
X_2640_ _4022_/Q _2640_/A2 _2784_/A2 _4019_/Q _2768_/A2 _4018_/Q _2645_/A1 VDD VDD
+ VSS VSS gf180mcu_fd_sc_mcu7t5v0__aoi222_1
X_2571_ _3977_/Q _2714_/A2 _2575_/A1 VDD VDD VSS VSS gf180mcu_fd_sc_mcu7t5v0__nor2_1
XFILLER_99_314 VDD VDD VSS VSS gf180mcu_fd_sc_mcu7t5v0__fillcap_16
XFILLER_113_146 VDD VDD VSS VSS gf180mcu_fd_sc_mcu7t5v0__fill_2
X_3123_ wire94/Z _3138_/A2 wire81/Z _3124_/B VDD VDD VSS VSS gf180mcu_fd_sc_mcu7t5v0__oai21_1
XFILLER_96_90 VDD VDD VSS VSS gf180mcu_fd_sc_mcu7t5v0__fillcap_8
X_3054_ _3844_/Q _3843_/Q _2934_/Z _3054_/A4 _3055_/B2 VDD VDD VSS VSS gf180mcu_fd_sc_mcu7t5v0__nor4_1
XFILLER_82_247 VDD VDD VSS VSS gf180mcu_fd_sc_mcu7t5v0__fillcap_4
X_2005_ _2005_/I _3082_/A1 VDD VDD VSS VSS gf180mcu_fd_sc_mcu7t5v0__clkinv_1
XTAP_TAPCELL_ROW_18_361 VDD VSS gf180mcu_fd_sc_mcu7t5v0__filltie
XFILLER_35_174 VDD VDD VSS VSS gf180mcu_fd_sc_mcu7t5v0__fill_2
XFILLER_23_347 VDD VDD VSS VSS gf180mcu_fd_sc_mcu7t5v0__fill_2
X_3956_ _3956_/D clkload9/I _3956_/Q VDD VDD VSS VSS gf180mcu_fd_sc_mcu7t5v0__dffq_1
XFILLER_50_177 VDD VDD VSS VSS gf180mcu_fd_sc_mcu7t5v0__fillcap_4
X_2907_ _3973_/Q _3915_/Q _2922_/C VDD VDD VSS VSS gf180mcu_fd_sc_mcu7t5v0__xor2_1
XFILLER_109_419 VDD VDD VSS VSS gf180mcu_fd_sc_mcu7t5v0__fill_1
X_3887_ _3887_/D _4162_/CLK _3887_/Q VDD VDD VSS VSS gf180mcu_fd_sc_mcu7t5v0__dffq_1
X_2838_ _2831_/Z _2839_/A2 _2844_/B VDD VDD VSS VSS gf180mcu_fd_sc_mcu7t5v0__nand2_1
X_2769_ _3954_/Q _3896_/Q _2776_/B VDD VDD VSS VSS gf180mcu_fd_sc_mcu7t5v0__nand2_1
XFILLER_104_179 VDD VDD VSS VSS gf180mcu_fd_sc_mcu7t5v0__fill_1
XFILLER_18_119 VDD VDD VSS VSS gf180mcu_fd_sc_mcu7t5v0__fill_1
XFILLER_58_277 VDD VDD VSS VSS gf180mcu_fd_sc_mcu7t5v0__fill_2
XTAP_TAPCELL_ROW_84_754 VDD VSS gf180mcu_fd_sc_mcu7t5v0__filltie
XTAP_TAPCELL_ROW_24_397 VDD VSS gf180mcu_fd_sc_mcu7t5v0__filltie
XFILLER_41_96 VDD VDD VSS VSS gf180mcu_fd_sc_mcu7t5v0__fill_1
XFILLER_96_317 VDD VDD VSS VSS gf180mcu_fd_sc_mcu7t5v0__fillcap_4
XFILLER_110_127 VDD VDD VSS VSS gf180mcu_fd_sc_mcu7t5v0__fill_1
XFILLER_49_244 VDD VDD VSS VSS gf180mcu_fd_sc_mcu7t5v0__fillcap_4
XTAP_TAPCELL_ROW_119_969 VDD VSS gf180mcu_fd_sc_mcu7t5v0__filltie
XFILLER_64_247 VDD VDD VSS VSS gf180mcu_fd_sc_mcu7t5v0__fillcap_32
XTAP_TAPCELL_ROW_15_342 VDD VSS gf180mcu_fd_sc_mcu7t5v0__filltie
X_3810_ _3810_/D _4021_/CLK _3810_/Q VDD VDD VSS VSS gf180mcu_fd_sc_mcu7t5v0__dffq_1
XFILLER_20_317 VDD VDD VSS VSS gf180mcu_fd_sc_mcu7t5v0__fill_1
XFILLER_32_177 VDD VDD VSS VSS gf180mcu_fd_sc_mcu7t5v0__fillcap_4
X_3741_ wire91/Z _3746_/A2 _3746_/B _3742_/A2 VDD VDD VSS VSS gf180mcu_fd_sc_mcu7t5v0__oai21_1
XFILLER_9_340 VDD VDD VSS VSS gf180mcu_fd_sc_mcu7t5v0__fillcap_8
X_3672_ hold184/Z _3676_/A2 _3720_/A1 _3748_/A2 _3673_/A2 VDD VDD VSS VSS gf180mcu_fd_sc_mcu7t5v0__aoi22_1
X_2623_ _2607_/B _2606_/B _2619_/B _2623_/B2 _3917_/Q _2625_/A2 VDD VDD VSS VSS gf180mcu_fd_sc_mcu7t5v0__aoi221_1
X_2554_ _2554_/I _3884_/D VDD VDD VSS VSS gf180mcu_fd_sc_mcu7t5v0__clkinv_1
XFILLER_114_422 VDD VDD VSS VSS gf180mcu_fd_sc_mcu7t5v0__fillcap_4
X_2485_ _2485_/A1 _2485_/A2 _2486_/I0 VDD VDD VSS VSS gf180mcu_fd_sc_mcu7t5v0__nand2_1
XFILLER_99_177 VDD VDD VSS VSS gf180mcu_fd_sc_mcu7t5v0__fillcap_4
X_4155_ _4155_/D _4155_/CLK _4200_/I VDD VDD VSS VSS gf180mcu_fd_sc_mcu7t5v0__dffq_1
X_3106_ wire94/I _3121_/A2 _3256_/B _3107_/B VDD VDD VSS VSS gf180mcu_fd_sc_mcu7t5v0__oai21_1
X_4086_ _4086_/D clkload4/I _4086_/Q VDD VDD VSS VSS gf180mcu_fd_sc_mcu7t5v0__dffq_1
XFILLER_55_258 VDD VDD VSS VSS gf180mcu_fd_sc_mcu7t5v0__fillcap_4
XTAP_TAPCELL_ROW_38_478 VDD VSS gf180mcu_fd_sc_mcu7t5v0__filltie
X_3037_ _4032_/Q _3275_/A1 _3190_/A1 _3992_/Q _3984_/Q _3037_/C2 _3038_/I VDD VDD
+ VSS VSS gf180mcu_fd_sc_mcu7t5v0__aoi222_1
X_3939_ _3939_/D _4170_/CLK _3939_/Q VDD VDD VSS VSS gf180mcu_fd_sc_mcu7t5v0__dffq_1
XFILLER_109_216 VDD VDD VSS VSS gf180mcu_fd_sc_mcu7t5v0__fill_2
XTAP_TAPCELL_ROW_21_378 VDD VSS gf180mcu_fd_sc_mcu7t5v0__filltie
XFILLER_105_422 VDD VDD VSS VSS gf180mcu_fd_sc_mcu7t5v0__fillcap_4
XFILLER_87_48 VDD VDD VSS VSS gf180mcu_fd_sc_mcu7t5v0__fillcap_4
XFILLER_120_425 VDD VDD VSS VSS gf180mcu_fd_sc_mcu7t5v0__fill_1
XFILLER_19_406 VDD VDD VSS VSS gf180mcu_fd_sc_mcu7t5v0__fillcap_8
XFILLER_36_63 VDD VDD VSS VSS gf180mcu_fd_sc_mcu7t5v0__fillcap_16
XFILLER_61_206 VDD VDD VSS VSS gf180mcu_fd_sc_mcu7t5v0__fillcap_4
XFILLER_14_177 VDD VDD VSS VSS gf180mcu_fd_sc_mcu7t5v0__fillcap_16
XTAP_TAPCELL_ROW_12_323 VDD VSS gf180mcu_fd_sc_mcu7t5v0__filltie
XFILLER_10_350 VDD VDD VSS VSS gf180mcu_fd_sc_mcu7t5v0__fillcap_32
XFILLER_6_387 VDD VDD VSS VSS gf180mcu_fd_sc_mcu7t5v0__fillcap_32
XFILLER_69_317 VDD VDD VSS VSS gf180mcu_fd_sc_mcu7t5v0__fill_1
X_2270_ _3870_/Q _3869_/Q _3868_/Q _3867_/Q _3821_/Q _3822_/Q _2270_/Z VDD VDD VSS
+ VSS gf180mcu_fd_sc_mcu7t5v0__mux4_1
X_1985_ _3960_/Q _3126_/A1 VDD VDD VSS VSS gf180mcu_fd_sc_mcu7t5v0__clkinv_1
XFILLER_20_169 VDD VDD VSS VSS gf180mcu_fd_sc_mcu7t5v0__fillcap_4
X_3724_ _3729_/B _3724_/A2 _4140_/Q _3728_/A1 VDD VDD VSS VSS gf180mcu_fd_sc_mcu7t5v0__oai21_1
X_3655_ _3655_/A1 _3655_/A2 _3655_/A3 _3656_/A2 VDD VDD VSS VSS gf180mcu_fd_sc_mcu7t5v0__nand3_1
X_2606_ _3221_/A1 _3915_/Q _2606_/B _2607_/C VDD VDD VSS VSS gf180mcu_fd_sc_mcu7t5v0__oai21_1
X_3586_ _3846_/Q _3675_/A2 _3720_/A3 VDD VDD VSS VSS gf180mcu_fd_sc_mcu7t5v0__nand2_1
X_2537_ _3876_/Q _3875_/Q _2549_/A2 _2529_/Z _2542_/A3 VDD VDD VSS VSS gf180mcu_fd_sc_mcu7t5v0__nand4_1
X_2468_ _2495_/C _2468_/A2 _2496_/B VDD VDD VSS VSS gf180mcu_fd_sc_mcu7t5v0__nor2_1
XFILLER_102_414 VDD VDD VSS VSS gf180mcu_fd_sc_mcu7t5v0__fillcap_8
X_2399_ _2399_/I _3843_/D VDD VDD VSS VSS gf180mcu_fd_sc_mcu7t5v0__clkinv_1
X_4138_ _4138_/D _4155_/CLK _4138_/Q VDD VDD VSS VSS gf180mcu_fd_sc_mcu7t5v0__dffq_1
X_4069_ _4069_/D _4079_/CLK _4069_/Q VDD VDD VSS VSS gf180mcu_fd_sc_mcu7t5v0__dffq_1
Xwire51 wire51/I wire51/Z VDD VDD VSS VSS gf180mcu_fd_sc_mcu7t5v0__buf_2
XFILLER_43_228 VDD VDD VSS VSS gf180mcu_fd_sc_mcu7t5v0__fillcap_8
XTAP_TAPCELL_ROW_121_986 VDD VSS gf180mcu_fd_sc_mcu7t5v0__filltie
XFILLER_19_225 VDD VDD VSS VSS gf180mcu_fd_sc_mcu7t5v0__fillcap_16
XTAP_TAPCELL_ROW_57_595 VDD VSS gf180mcu_fd_sc_mcu7t5v0__filltie
XFILLER_63_72 VDD VDD VSS VSS gf180mcu_fd_sc_mcu7t5v0__fillcap_4
XFILLER_97_8 VDD VDD VSS VSS gf180mcu_fd_sc_mcu7t5v0__fill_2
XFILLER_8_45 VDD VDD VSS VSS gf180mcu_fd_sc_mcu7t5v0__fill_2
XFILLER_8_34 VDD VDD VSS VSS gf180mcu_fd_sc_mcu7t5v0__fill_1
XTAP_TAPCELL_ROW_40_495 VDD VSS gf180mcu_fd_sc_mcu7t5v0__filltie
X_3440_ _4079_/Q _3436_/Z _3440_/B _4079_/D VDD VDD VSS VSS gf180mcu_fd_sc_mcu7t5v0__aoi21_1
Xdelaybuf_0_signal_clock signal_input delaybuf_1_signal_clock/I VDD VDD VSS VSS gf180mcu_fd_sc_mcu7t5v0__clkbuf_16
X_3371_ _4137_/Q _3384_/A2 _4071_/Q _3698_/A1 _3372_/C VDD VDD VSS VSS gf180mcu_fd_sc_mcu7t5v0__oai22_1
X_2322_ _2322_/A1 _2360_/A2 _2323_/C VDD VDD VSS VSS gf180mcu_fd_sc_mcu7t5v0__nand2_1
X_2253_ _3833_/Q _3834_/Q _2333_/B VDD VDD VSS VSS gf180mcu_fd_sc_mcu7t5v0__nand2_1
XFILLER_84_128 VDD VDD VSS VSS gf180mcu_fd_sc_mcu7t5v0__fill_1
X_2184_ _2184_/A1 _2184_/A2 hold195/I VDD VDD VSS VSS gf180mcu_fd_sc_mcu7t5v0__nor2_1
XTAP_TAPCELL_ROW_48_540 VDD VSS gf180mcu_fd_sc_mcu7t5v0__filltie
XFILLER_25_217 VDD VDD VSS VSS gf180mcu_fd_sc_mcu7t5v0__fillcap_32
XFILLER_80_367 VDD VDD VSS VSS gf180mcu_fd_sc_mcu7t5v0__fillcap_4
XTAP_TAPCELL_ROW_31_440 VDD VSS gf180mcu_fd_sc_mcu7t5v0__filltie
Xclkbuf_1_0__f_signal_input clkbuf_0_signal_input/Z _3454_/A1 VDD VDD VSS VSS gf180mcu_fd_sc_mcu7t5v0__clkbuf_16
XFILLER_119_344 VDD VDD VSS VSS gf180mcu_fd_sc_mcu7t5v0__fillcap_4
X_1968_ _1968_/I _3162_/A1 VDD VDD VSS VSS gf180mcu_fd_sc_mcu7t5v0__clkinv_1
X_3707_ _3707_/A1 _3717_/A2 _3707_/B _4134_/D VDD VDD VSS VSS gf180mcu_fd_sc_mcu7t5v0__aoi21_1
X_1899_ _4075_/Q _3370_/A2 VDD VDD VSS VSS gf180mcu_fd_sc_mcu7t5v0__clkinv_1
X_3638_ _4128_/Q _3638_/A2 _3723_/A2 _4146_/Q _3639_/C VDD VDD VSS VSS gf180mcu_fd_sc_mcu7t5v0__aoi22_1
X_3569_ _4109_/Q _3569_/A2 _3564_/Z _3570_/A3 VDD VDD VSS VSS gf180mcu_fd_sc_mcu7t5v0__nand3_1
XFILLER_102_244 VDD VDD VSS VSS gf180mcu_fd_sc_mcu7t5v0__fill_1
XFILLER_102_299 VDD VDD VSS VSS gf180mcu_fd_sc_mcu7t5v0__fillcap_16
XFILLER_16_239 VDD VDD VSS VSS gf180mcu_fd_sc_mcu7t5v0__fillcap_4
XFILLER_17_65 VDD VDD VSS VSS gf180mcu_fd_sc_mcu7t5v0__fillcap_4
XFILLER_71_345 VDD VDD VSS VSS gf180mcu_fd_sc_mcu7t5v0__fillcap_4
XFILLER_31_209 VDD VDD VSS VSS gf180mcu_fd_sc_mcu7t5v0__fill_1
XTAP_TAPCELL_ROW_54_576 VDD VSS gf180mcu_fd_sc_mcu7t5v0__filltie
XFILLER_12_423 VDD VDD VSS VSS gf180mcu_fd_sc_mcu7t5v0__fill_2
XFILLER_33_31 VDD VDD VSS VSS gf180mcu_fd_sc_mcu7t5v0__fillcap_4
XPHY_EDGE_ROW_18_Left_140 VDD VSS gf180mcu_fd_sc_mcu7t5v0__endcap
XTAP_TAPCELL_ROW_45_521 VDD VSS gf180mcu_fd_sc_mcu7t5v0__filltie
XFILLER_62_367 VDD VDD VSS VSS gf180mcu_fd_sc_mcu7t5v0__fillcap_4
X_2940_ _3842_/Q _2940_/A2 _2940_/A3 _2957_/A1 VDD VDD VSS VSS gf180mcu_fd_sc_mcu7t5v0__nand3_1
X_2871_ _2929_/A1 _2871_/A2 _3909_/D VDD VDD VSS VSS gf180mcu_fd_sc_mcu7t5v0__nor2_1
XFILLER_88_4 VDD VDD VSS VSS gf180mcu_fd_sc_mcu7t5v0__fill_1
XFILLER_116_303 VDD VDD VSS VSS gf180mcu_fd_sc_mcu7t5v0__fillcap_4
Xclkbuf_1_0__f__1476_ clkbuf_0__1476_/Z _3537_/A2 VDD VDD VSS VSS gf180mcu_fd_sc_mcu7t5v0__clkbuf_16
X_3423_ _4073_/Q _4072_/Q _4071_/Q _3414_/Z _3423_/Z VDD VDD VSS VSS gf180mcu_fd_sc_mcu7t5v0__and4_1
XFILLER_89_209 VDD VDD VSS VSS gf180mcu_fd_sc_mcu7t5v0__fill_1
X_3354_ _4058_/Q _4057_/Q _4056_/Q _3345_/Z _3354_/Z VDD VDD VSS VSS gf180mcu_fd_sc_mcu7t5v0__and4_1
XFILLER_97_220 VDD VDD VSS VSS gf180mcu_fd_sc_mcu7t5v0__fill_1
X_2305_ _3813_/Q _2300_/S _2306_/B VDD VDD VSS VSS gf180mcu_fd_sc_mcu7t5v0__nand2_1
X_3285_ _3285_/A1 _3291_/A2 _3285_/B _4035_/D VDD VDD VSS VSS gf180mcu_fd_sc_mcu7t5v0__aoi21_1
X_2236_ _3536_/A1 _2111_/Z _2236_/B _3800_/D VDD VDD VSS VSS gf180mcu_fd_sc_mcu7t5v0__aoi21_1
XFILLER_57_139 VDD VDD VSS VSS gf180mcu_fd_sc_mcu7t5v0__fill_1
XFILLER_65_172 VDD VDD VSS VSS gf180mcu_fd_sc_mcu7t5v0__fillcap_4
X_2167_ _4057_/Q _2242_/A2 _2169_/A1 VDD VDD VSS VSS gf180mcu_fd_sc_mcu7t5v0__nor2_1
X_2098_ _3838_/Q _2940_/A2 _2098_/A3 _2105_/A1 VDD VDD VSS VSS gf180mcu_fd_sc_mcu7t5v0__nand3_1
XFILLER_13_209 VDD VDD VSS VSS gf180mcu_fd_sc_mcu7t5v0__fill_1
XFILLER_110_69 VDD VDD VSS VSS gf180mcu_fd_sc_mcu7t5v0__fill_2
XTAP_TAPCELL_ROW_51_557 VDD VSS gf180mcu_fd_sc_mcu7t5v0__filltie
XFILLER_107_358 VDD VDD VSS VSS gf180mcu_fd_sc_mcu7t5v0__fillcap_8
XFILLER_28_53 VDD VDD VSS VSS gf180mcu_fd_sc_mcu7t5v0__fill_2
X_3460__118 _3460__118/I _3465_/A2 VDD VDD VSS VSS gf180mcu_fd_sc_mcu7t5v0__clkinv_1
XFILLER_71_142 VDD VDD VSS VSS gf180mcu_fd_sc_mcu7t5v0__fillcap_16
XTAP_TAPCELL_ROW_42_502 VDD VSS gf180mcu_fd_sc_mcu7t5v0__filltie
XFILLER_71_197 VDD VDD VSS VSS gf180mcu_fd_sc_mcu7t5v0__fillcap_4
XFILLER_113_306 VDD VDD VSS VSS gf180mcu_fd_sc_mcu7t5v0__fillcap_8
XFILLER_5_68 VDD VDD VSS VSS gf180mcu_fd_sc_mcu7t5v0__fill_2
XFILLER_69_60 VDD VDD VSS VSS gf180mcu_fd_sc_mcu7t5v0__fill_2
X_3070_ _3070_/A1 _3082_/A2 _3070_/B _3934_/D VDD VDD VSS VSS gf180mcu_fd_sc_mcu7t5v0__aoi21_1
X_2021_ _3811_/Q _2536_/A1 VDD VDD VSS VSS gf180mcu_fd_sc_mcu7t5v0__clkinv_1
XFILLER_35_323 VDD VDD VSS VSS gf180mcu_fd_sc_mcu7t5v0__fill_1
XFILLER_47_150 VDD VDD VSS VSS gf180mcu_fd_sc_mcu7t5v0__fill_2
XFILLER_35_356 VDD VDD VSS VSS gf180mcu_fd_sc_mcu7t5v0__fillcap_4
XTAP_TAPCELL_ROW_73_693 VDD VSS gf180mcu_fd_sc_mcu7t5v0__filltie
X_3972_ _3972_/D _4169_/CLK _3972_/Q VDD VDD VSS VSS gf180mcu_fd_sc_mcu7t5v0__dffq_1
X_2923_ _3973_/Q _3915_/Q _2923_/A3 _2924_/A2 VDD VDD VSS VSS gf180mcu_fd_sc_mcu7t5v0__nand3_1
X_2854_ _2929_/A1 _2852_/Z _2854_/A3 _3907_/D VDD VDD VSS VSS gf180mcu_fd_sc_mcu7t5v0__nor3_1
X_2785_ _2798_/A2 _2785_/A2 _2785_/Z VDD VDD VSS VSS gf180mcu_fd_sc_mcu7t5v0__xor2_1
Xhold202 _3940_/Q _2005_/I VDD VDD VSS VSS gf180mcu_fd_sc_mcu7t5v0__dlyc_1
Xhold235 _4053_/Q hold235/Z VDD VDD VSS VSS gf180mcu_fd_sc_mcu7t5v0__dlyc_1
Xhold224 _4046_/Q hold224/Z VDD VDD VSS VSS gf180mcu_fd_sc_mcu7t5v0__dlyc_1
Xhold213 _3988_/Q _1957_/I VDD VDD VSS VSS gf180mcu_fd_sc_mcu7t5v0__dlyc_1
XFILLER_104_317 VDD VDD VSS VSS gf180mcu_fd_sc_mcu7t5v0__fillcap_4
XFILLER_104_306 VDD VDD VSS VSS gf180mcu_fd_sc_mcu7t5v0__fillcap_8
X_3406_ _3401_/I _3404_/Z _3406_/A3 _4066_/D VDD VDD VSS VSS gf180mcu_fd_sc_mcu7t5v0__nor3_1
X_3337_ _3395_/A1 _3337_/A2 _3336_/Z _4052_/D VDD VDD VSS VSS gf180mcu_fd_sc_mcu7t5v0__nor3_1
XFILLER_85_212 VDD VDD VSS VSS gf180mcu_fd_sc_mcu7t5v0__fill_1
XFILLER_105_36 VDD VDD VSS VSS gf180mcu_fd_sc_mcu7t5v0__fill_1
X_3268_ _3268_/A1 _3268_/A2 _3268_/B _4027_/D VDD VDD VSS VSS gf180mcu_fd_sc_mcu7t5v0__aoi21_1
X_2219_ _4092_/Q _2248_/A2 _2221_/A1 VDD VDD VSS VSS gf180mcu_fd_sc_mcu7t5v0__nor2_1
X_3199_ wire90/Z _3206_/A2 wire81/Z _3200_/B VDD VDD VSS VSS gf180mcu_fd_sc_mcu7t5v0__oai21_1
XFILLER_26_323 VDD VDD VSS VSS gf180mcu_fd_sc_mcu7t5v0__fill_1
XFILLER_53_142 VDD VDD VSS VSS gf180mcu_fd_sc_mcu7t5v0__fill_1
XFILLER_5_227 VDD VDD VSS VSS gf180mcu_fd_sc_mcu7t5v0__fill_1
XFILLER_107_133 VDD VDD VSS VSS gf180mcu_fd_sc_mcu7t5v0__fill_1
XFILLER_107_188 VDD VDD VSS VSS gf180mcu_fd_sc_mcu7t5v0__fill_2
XFILLER_1_422 VDD VDD VSS VSS gf180mcu_fd_sc_mcu7t5v0__fillcap_4
XFILLER_76_256 VDD VDD VSS VSS gf180mcu_fd_sc_mcu7t5v0__fill_1
XTAP_TAPCELL_ROW_87_774 VDD VSS gf180mcu_fd_sc_mcu7t5v0__filltie
XFILLER_55_95 VDD VDD VSS VSS gf180mcu_fd_sc_mcu7t5v0__fillcap_4
XFILLER_44_197 VDD VDD VSS VSS gf180mcu_fd_sc_mcu7t5v0__fill_2
XTAP_TAPCELL_ROW_70_674 VDD VSS gf180mcu_fd_sc_mcu7t5v0__filltie
XFILLER_65_6 VDD VDD VSS VSS gf180mcu_fd_sc_mcu7t5v0__fill_2
X_2570_ _3980_/Q _2633_/C1 _2579_/A1 VDD VDD VSS VSS gf180mcu_fd_sc_mcu7t5v0__nor2_1
XFILLER_113_136 VDD VDD VSS VSS gf180mcu_fd_sc_mcu7t5v0__fillcap_4
XFILLER_67_212 VDD VDD VSS VSS gf180mcu_fd_sc_mcu7t5v0__fillcap_4
X_3122_ _3122_/A1 _3275_/A2 _3136_/A2 VDD VDD VSS VSS gf180mcu_fd_sc_mcu7t5v0__nand2_1
XFILLER_55_407 VDD VDD VSS VSS gf180mcu_fd_sc_mcu7t5v0__fillcap_4
X_3053_ _3842_/Q _3053_/A2 _3840_/Q _3054_/A4 VDD VDD VSS VSS gf180mcu_fd_sc_mcu7t5v0__aoi21_1
X_2004_ _3941_/Q _3085_/A1 VDD VDD VSS VSS gf180mcu_fd_sc_mcu7t5v0__clkinv_1
XTAP_TAPCELL_ROW_18_362 VDD VSS gf180mcu_fd_sc_mcu7t5v0__filltie
XFILLER_50_123 VDD VDD VSS VSS gf180mcu_fd_sc_mcu7t5v0__fillcap_8
X_3955_ _3955_/D clkload9/I _3955_/Q VDD VDD VSS VSS gf180mcu_fd_sc_mcu7t5v0__dffq_1
X_2906_ _3973_/Q _3915_/Q _2920_/A1 VDD VDD VSS VSS gf180mcu_fd_sc_mcu7t5v0__nand2_1
X_3886_ _3886_/D _4017_/CLK _3886_/Q VDD VDD VSS VSS gf180mcu_fd_sc_mcu7t5v0__dffq_1
X_2837_ wire31/Z _2819_/Z _2865_/A2 _2837_/B _2839_/A2 VDD VDD VSS VSS gf180mcu_fd_sc_mcu7t5v0__oai31_1
X_2768_ _3113_/A1 _2768_/A2 _2779_/C VDD VDD VSS VSS gf180mcu_fd_sc_mcu7t5v0__nand2_1
X_2699_ _2699_/A1 _2699_/A2 _2699_/B _3917_/Q _2700_/A2 VDD VDD VSS VSS gf180mcu_fd_sc_mcu7t5v0__aoi211_1
XFILLER_104_103 VDD VDD VSS VSS gf180mcu_fd_sc_mcu7t5v0__fill_2
XFILLER_104_125 VDD VDD VSS VSS gf180mcu_fd_sc_mcu7t5v0__fillcap_8
XFILLER_104_158 VDD VDD VSS VSS gf180mcu_fd_sc_mcu7t5v0__fillcap_16
XFILLER_76_28 VDD VDD VSS VSS gf180mcu_fd_sc_mcu7t5v0__fill_1
XFILLER_73_248 VDD VDD VSS VSS gf180mcu_fd_sc_mcu7t5v0__fill_2
XTAP_TAPCELL_ROW_84_755 VDD VSS gf180mcu_fd_sc_mcu7t5v0__filltie
XFILLER_26_131 VDD VDD VSS VSS gf180mcu_fd_sc_mcu7t5v0__fill_1
XFILLER_14_304 VDD VDD VSS VSS gf180mcu_fd_sc_mcu7t5v0__fill_2
XFILLER_25_98 VDD VDD VSS VSS gf180mcu_fd_sc_mcu7t5v0__fill_1
XTAP_TAPCELL_ROW_24_398 VDD VSS gf180mcu_fd_sc_mcu7t5v0__filltie
XFILLER_49_223 VDD VDD VSS VSS gf180mcu_fd_sc_mcu7t5v0__fill_1
XTAP_TAPCELL_ROW_75_700 VDD VSS gf180mcu_fd_sc_mcu7t5v0__filltie
XFILLER_64_237 VDD VDD VSS VSS gf180mcu_fd_sc_mcu7t5v0__fillcap_8
XFILLER_17_164 VDD VDD VSS VSS gf180mcu_fd_sc_mcu7t5v0__fill_1
XFILLER_72_292 VDD VDD VSS VSS gf180mcu_fd_sc_mcu7t5v0__fillcap_16
XTAP_TAPCELL_ROW_15_343 VDD VSS gf180mcu_fd_sc_mcu7t5v0__filltie
X_3740_ hold137/Z _3725_/Z _3742_/A1 VDD VDD VSS VSS gf180mcu_fd_sc_mcu7t5v0__nor2_1
XFILLER_9_352 VDD VDD VSS VSS gf180mcu_fd_sc_mcu7t5v0__fillcap_64
X_3671_ _3671_/A1 _3720_/A3 _3748_/A2 VDD VDD VSS VSS gf180mcu_fd_sc_mcu7t5v0__nor2_1
X_2622_ _2616_/C _2622_/A2 _2622_/B _2623_/B2 VDD VDD VSS VSS gf180mcu_fd_sc_mcu7t5v0__oai21_1
X_2553_ hold131/Z _3256_/B _2554_/I VDD VDD VSS VSS gf180mcu_fd_sc_mcu7t5v0__nand2_1
X_2484_ _4118_/Q _3921_/Q _2496_/B _2485_/A2 VDD VDD VSS VSS gf180mcu_fd_sc_mcu7t5v0__oai21_1
XFILLER_87_307 VDD VDD VSS VSS gf180mcu_fd_sc_mcu7t5v0__fill_2
XFILLER_99_156 VDD VDD VSS VSS gf180mcu_fd_sc_mcu7t5v0__fillcap_4
X_4154_ _4154_/D _4155_/CLK _4199_/I VDD VDD VSS VSS gf180mcu_fd_sc_mcu7t5v0__dffq_1
X_3105_ _3105_/A1 _3241_/A2 _3108_/A2 VDD VDD VSS VSS gf180mcu_fd_sc_mcu7t5v0__nand2_1
X_4085_ _4085_/D clkload4/I _4085_/Q VDD VDD VSS VSS gf180mcu_fd_sc_mcu7t5v0__dffq_1
X_3036_ _4016_/Q _3036_/A2 _3036_/B1 _3960_/Q _3049_/B1 _4166_/Q _3045_/A2 VDD VDD
+ VSS VSS gf180mcu_fd_sc_mcu7t5v0__aoi222_1
XTAP_TAPCELL_ROW_38_479 VDD VSS gf180mcu_fd_sc_mcu7t5v0__filltie
XFILLER_23_112 VDD VDD VSS VSS gf180mcu_fd_sc_mcu7t5v0__fill_1
XTAP_TAPCELL_ROW_81_736 VDD VSS gf180mcu_fd_sc_mcu7t5v0__filltie
X_3938_ _3938_/D _4170_/CLK _3938_/Q VDD VDD VSS VSS gf180mcu_fd_sc_mcu7t5v0__dffq_1
XTAP_TAPCELL_ROW_21_379 VDD VSS gf180mcu_fd_sc_mcu7t5v0__filltie
X_3869_ _3869_/D _4021_/CLK _3869_/Q VDD VDD VSS VSS gf180mcu_fd_sc_mcu7t5v0__dffq_1
XFILLER_11_67 VDD VDD VSS VSS gf180mcu_fd_sc_mcu7t5v0__fill_2
XFILLER_19_418 VDD VDD VSS VSS gf180mcu_fd_sc_mcu7t5v0__fill_2
XTAP_TAPCELL_ROW_29_424 VDD VSS gf180mcu_fd_sc_mcu7t5v0__filltie
XFILLER_86_395 VDD VDD VSS VSS gf180mcu_fd_sc_mcu7t5v0__fill_2
XFILLER_36_31 VDD VDD VSS VSS gf180mcu_fd_sc_mcu7t5v0__fillcap_4
XTAP_TAPCELL_ROW_12_324 VDD VSS gf180mcu_fd_sc_mcu7t5v0__filltie
XFILLER_6_311 VDD VDD VSS VSS gf180mcu_fd_sc_mcu7t5v0__fillcap_4
XFILLER_52_96 VDD VDD VSS VSS gf180mcu_fd_sc_mcu7t5v0__fill_1
XFILLER_10_384 VDD VDD VSS VSS gf180mcu_fd_sc_mcu7t5v0__fill_1
XFILLER_108_261 VDD VDD VSS VSS gf180mcu_fd_sc_mcu7t5v0__fillcap_4
XFILLER_111_415 VDD VDD VSS VSS gf180mcu_fd_sc_mcu7t5v0__fillcap_4
XFILLER_96_104 VDD VDD VSS VSS gf180mcu_fd_sc_mcu7t5v0__fill_1
XFILLER_28_6 VDD VDD VSS VSS gf180mcu_fd_sc_mcu7t5v0__fillcap_16
XFILLER_77_82 VDD VDD VSS VSS gf180mcu_fd_sc_mcu7t5v0__fill_2
XFILLER_77_340 VDD VDD VSS VSS gf180mcu_fd_sc_mcu7t5v0__fill_2
XTAP_TAPCELL_ROW_115_940 VDD VSS gf180mcu_fd_sc_mcu7t5v0__filltie
XFILLER_92_387 VDD VDD VSS VSS gf180mcu_fd_sc_mcu7t5v0__fill_2
XFILLER_60_262 VDD VDD VSS VSS gf180mcu_fd_sc_mcu7t5v0__fill_2
X_1984_ _3961_/Q _3128_/A1 VDD VDD VSS VSS gf180mcu_fd_sc_mcu7t5v0__clkinv_1
XFILLER_20_148 VDD VDD VSS VSS gf180mcu_fd_sc_mcu7t5v0__fill_1
X_3723_ _3587_/B _3723_/A2 _3723_/B _3724_/A2 VDD VDD VSS VSS gf180mcu_fd_sc_mcu7t5v0__aoi21_1
X_3654_ _3796_/Q wire71/Z _3664_/B1 _3804_/Q _3655_/A3 VDD VDD VSS VSS gf180mcu_fd_sc_mcu7t5v0__aoi22_1
X_2605_ _4006_/Q _2915_/A2 _2606_/B VDD VDD VSS VSS gf180mcu_fd_sc_mcu7t5v0__nand2_1
XFILLER_106_209 VDD VDD VSS VSS gf180mcu_fd_sc_mcu7t5v0__fillcap_16
X_3585_ _3579_/B _3585_/A2 _4113_/D VDD VDD VSS VSS gf180mcu_fd_sc_mcu7t5v0__nor2_1
XFILLER_114_253 VDD VDD VSS VSS gf180mcu_fd_sc_mcu7t5v0__fill_1
XFILLER_114_231 VDD VDD VSS VSS gf180mcu_fd_sc_mcu7t5v0__fill_1
X_2536_ _2536_/A1 _2543_/A2 _2540_/A2 _2536_/B2 _3875_/D VDD VDD VSS VSS gf180mcu_fd_sc_mcu7t5v0__oai22_1
XFILLER_114_264 VDD VDD VSS VSS gf180mcu_fd_sc_mcu7t5v0__fill_1
X_2467_ _4123_/Q _3928_/Q _2468_/A2 VDD VDD VSS VSS gf180mcu_fd_sc_mcu7t5v0__nor2_1
XFILLER_87_137 VDD VDD VSS VSS gf180mcu_fd_sc_mcu7t5v0__fill_2
X_2398_ _3877_/Q _2383_/I _2400_/B1 _3843_/Q _2399_/I VDD VDD VSS VSS gf180mcu_fd_sc_mcu7t5v0__aoi22_1
XFILLER_113_14 VDD VDD VSS VSS gf180mcu_fd_sc_mcu7t5v0__fill_2
XFILLER_68_384 VDD VDD VSS VSS gf180mcu_fd_sc_mcu7t5v0__fill_1
X_4137_ _4137_/D _4155_/CLK _4137_/Q VDD VDD VSS VSS gf180mcu_fd_sc_mcu7t5v0__dffq_1
X_4068_ _4068_/D _4073_/CLK _4068_/Q VDD VDD VSS VSS gf180mcu_fd_sc_mcu7t5v0__dffq_1
XFILLER_73_18 VDD VDD VSS VSS gf180mcu_fd_sc_mcu7t5v0__fillcap_4
X_3019_ _2345_/C _3019_/A2 _3924_/D VDD VDD VSS VSS gf180mcu_fd_sc_mcu7t5v0__nor2_1
XFILLER_11_104 VDD VDD VSS VSS gf180mcu_fd_sc_mcu7t5v0__fill_1
XFILLER_51_273 VDD VDD VSS VSS gf180mcu_fd_sc_mcu7t5v0__fill_2
XTAP_TAPCELL_ROW_121_987 VDD VSS gf180mcu_fd_sc_mcu7t5v0__filltie
XTAP_TAPCELL_ROW_121_976 VDD VSS gf180mcu_fd_sc_mcu7t5v0__filltie
XFILLER_98_37 VDD VDD VSS VSS gf180mcu_fd_sc_mcu7t5v0__fill_2
XFILLER_74_321 VDD VDD VSS VSS gf180mcu_fd_sc_mcu7t5v0__fill_1
XFILLER_86_181 VDD VDD VSS VSS gf180mcu_fd_sc_mcu7t5v0__fill_2
XTAP_TAPCELL_ROW_57_596 VDD VSS gf180mcu_fd_sc_mcu7t5v0__filltie
XFILLER_103_80 VDD VDD VSS VSS gf180mcu_fd_sc_mcu7t5v0__fill_2
XFILLER_103_91 VDD VDD VSS VSS gf180mcu_fd_sc_mcu7t5v0__fillcap_16
XFILLER_30_413 VDD VDD VSS VSS gf180mcu_fd_sc_mcu7t5v0__fillcap_8
XFILLER_42_251 VDD VDD VSS VSS gf180mcu_fd_sc_mcu7t5v0__fill_1
XFILLER_42_240 VDD VDD VSS VSS gf180mcu_fd_sc_mcu7t5v0__fillcap_4
X_3370_ _4135_/Q _3370_/A2 _4071_/Q _3698_/A1 _3370_/C _3386_/A1 VDD VDD VSS VSS gf180mcu_fd_sc_mcu7t5v0__aoi221_1
XFILLER_111_212 VDD VDD VSS VSS gf180mcu_fd_sc_mcu7t5v0__fillcap_4
X_2321_ _3815_/Q _2321_/I1 _2321_/S _3815_/D VDD VDD VSS VSS gf180mcu_fd_sc_mcu7t5v0__mux2_2
XFILLER_69_115 VDD VDD VSS VSS gf180mcu_fd_sc_mcu7t5v0__fillcap_8
XFILLER_111_234 VDD VDD VSS VSS gf180mcu_fd_sc_mcu7t5v0__fill_2
X_2252_ _3824_/Q _2360_/A1 _2357_/A1 _3821_/Q _2252_/Z VDD VDD VSS VSS gf180mcu_fd_sc_mcu7t5v0__and4_1
XFILLER_84_118 VDD VDD VSS VSS gf180mcu_fd_sc_mcu7t5v0__fillcap_8
X_2183_ _3781_/Q _2243_/A2 _3746_/B _2184_/A2 VDD VDD VSS VSS gf180mcu_fd_sc_mcu7t5v0__oai21_1
XTAP_TAPCELL_ROW_48_541 VDD VSS gf180mcu_fd_sc_mcu7t5v0__filltie
XFILLER_92_151 VDD VDD VSS VSS gf180mcu_fd_sc_mcu7t5v0__fillcap_4
XTAP_TAPCELL_ROW_31_441 VDD VSS gf180mcu_fd_sc_mcu7t5v0__filltie
XFILLER_119_323 VDD VDD VSS VSS gf180mcu_fd_sc_mcu7t5v0__fillcap_8
X_1967_ _1967_/I _3164_/A1 VDD VDD VSS VSS gf180mcu_fd_sc_mcu7t5v0__clkinv_1
X_3706_ _3751_/I1 _3717_/A2 _3746_/B _3707_/B VDD VDD VSS VSS gf180mcu_fd_sc_mcu7t5v0__oai21_1
X_1898_ _4076_/Q _3375_/A2 VDD VDD VSS VSS gf180mcu_fd_sc_mcu7t5v0__clkinv_1
X_3637_ _4197_/I _3748_/A1 _3700_/A1 _4136_/Q _3639_/B VDD VDD VSS VSS gf180mcu_fd_sc_mcu7t5v0__aoi22_1
X_3568_ _3582_/A2 _3564_/Z _4109_/Q _3571_/A1 VDD VDD VSS VSS gf180mcu_fd_sc_mcu7t5v0__aoi21_1
X_2519_ _2380_/Z _2516_/Z _2520_/B VDD VDD VSS VSS gf180mcu_fd_sc_mcu7t5v0__nor2_1
XFILLER_88_424 VDD VDD VSS VSS gf180mcu_fd_sc_mcu7t5v0__fill_2
X_3499_ _3552_/C _3499_/A2 _4088_/D VDD VDD VSS VSS gf180mcu_fd_sc_mcu7t5v0__nor2_1
XFILLER_75_129 VDD VDD VSS VSS gf180mcu_fd_sc_mcu7t5v0__fill_2
XFILLER_102_289 VDD VDD VSS VSS gf180mcu_fd_sc_mcu7t5v0__fillcap_4
XFILLER_56_387 VDD VDD VSS VSS gf180mcu_fd_sc_mcu7t5v0__fill_2
XTAP_TAPCELL_ROW_54_577 VDD VSS gf180mcu_fd_sc_mcu7t5v0__filltie
XFILLER_33_65 VDD VDD VSS VSS gf180mcu_fd_sc_mcu7t5v0__fill_1
XFILLER_58_95 VDD VDD VSS VSS gf180mcu_fd_sc_mcu7t5v0__fillcap_8
XFILLER_74_162 VDD VDD VSS VSS gf180mcu_fd_sc_mcu7t5v0__fillcap_4
XTAP_TAPCELL_ROW_45_522 VDD VSS gf180mcu_fd_sc_mcu7t5v0__filltie
X_2870_ _2897_/A1 _2868_/Z _2871_/A2 VDD VDD VSS VSS gf180mcu_fd_sc_mcu7t5v0__xnor2_1
X_3422_ _4072_/Q _3418_/Z _4073_/Q _3424_/A2 VDD VDD VSS VSS gf180mcu_fd_sc_mcu7t5v0__aoi21_1
XFILLER_99_80 VDD VDD VSS VSS gf180mcu_fd_sc_mcu7t5v0__fill_1
X_3353_ hold232/Z _3351_/Z _3355_/A2 VDD VDD VSS VSS gf180mcu_fd_sc_mcu7t5v0__nor2_1
X_2304_ _2536_/A1 _2300_/S _2304_/B _3812_/D VDD VDD VSS VSS gf180mcu_fd_sc_mcu7t5v0__oai21_1
X_3284_ wire90/Z _3291_/A2 wire81/Z _3285_/B VDD VDD VSS VSS gf180mcu_fd_sc_mcu7t5v0__oai21_1
X_2235_ _3800_/Q _2111_/Z _3746_/B _2236_/B VDD VDD VSS VSS gf180mcu_fd_sc_mcu7t5v0__oai21_1
XTAP_TAPCELL_ROW_68_658 VDD VSS gf180mcu_fd_sc_mcu7t5v0__filltie
X_2166_ _2166_/A1 _2166_/A2 _3775_/D VDD VDD VSS VSS gf180mcu_fd_sc_mcu7t5v0__nor2_1
XFILLER_38_387 VDD VDD VSS VSS gf180mcu_fd_sc_mcu7t5v0__fillcap_4
X_2097_ _3842_/Q _2097_/A2 _2098_/A3 VDD VDD VSS VSS gf180mcu_fd_sc_mcu7t5v0__nor2_1
XFILLER_110_26 VDD VDD VSS VSS gf180mcu_fd_sc_mcu7t5v0__fill_1
XFILLER_80_187 VDD VDD VSS VSS gf180mcu_fd_sc_mcu7t5v0__fillcap_16
XPHY_EDGE_ROW_3_Right_3 VDD VSS gf180mcu_fd_sc_mcu7t5v0__endcap
XTAP_TAPCELL_ROW_51_558 VDD VSS gf180mcu_fd_sc_mcu7t5v0__filltie
X_2999_ hold138/Z _2999_/A2 _2999_/B1 _2999_/B2 _3000_/A2 VDD VDD VSS VSS gf180mcu_fd_sc_mcu7t5v0__aoi22_1
XFILLER_88_243 VDD VDD VSS VSS gf180mcu_fd_sc_mcu7t5v0__fill_2
XFILLER_88_276 VDD VDD VSS VSS gf180mcu_fd_sc_mcu7t5v0__fillcap_4
XFILLER_91_419 VDD VDD VSS VSS gf180mcu_fd_sc_mcu7t5v0__fill_1
XTAP_TAPCELL_ROW_42_503 VDD VSS gf180mcu_fd_sc_mcu7t5v0__filltie
XFILLER_8_203 VDD VDD VSS VSS gf180mcu_fd_sc_mcu7t5v0__fill_1
XFILLER_8_247 VDD VDD VSS VSS gf180mcu_fd_sc_mcu7t5v0__fillcap_64
XFILLER_60_63 VDD VDD VSS VSS gf180mcu_fd_sc_mcu7t5v0__fillcap_16
XFILLER_69_72 VDD VDD VSS VSS gf180mcu_fd_sc_mcu7t5v0__fill_2
XFILLER_106_370 VDD VDD VSS VSS gf180mcu_fd_sc_mcu7t5v0__fillcap_8
X_2020_ _3812_/Q _2487_/A1 VDD VDD VSS VSS gf180mcu_fd_sc_mcu7t5v0__clkinv_1
XFILLER_35_379 VDD VDD VSS VSS gf180mcu_fd_sc_mcu7t5v0__fillcap_32
X_3971_ _3971_/D _4170_/CLK _3971_/Q VDD VDD VSS VSS gf180mcu_fd_sc_mcu7t5v0__dffq_1
X_2922_ _2922_/A1 _2922_/A2 _2922_/B _2922_/C _2926_/A1 VDD VDD VSS VSS gf180mcu_fd_sc_mcu7t5v0__oai211_1
X_2853_ _2848_/Z _2858_/A2 _2854_/A3 VDD VDD VSS VSS gf180mcu_fd_sc_mcu7t5v0__nor2_1
X_2784_ _3115_/A1 _2784_/A2 _2784_/B _2785_/A2 VDD VDD VSS VSS gf180mcu_fd_sc_mcu7t5v0__oai21_1
Xhold203 _3864_/Q hold203/Z VDD VDD VSS VSS gf180mcu_fd_sc_mcu7t5v0__dlyc_1
Xhold225 _3881_/Q hold225/Z VDD VDD VSS VSS gf180mcu_fd_sc_mcu7t5v0__dlyc_1
Xhold214 _4045_/Q hold214/Z VDD VDD VSS VSS gf180mcu_fd_sc_mcu7t5v0__dlyc_1
XFILLER_116_189 VDD VDD VSS VSS gf180mcu_fd_sc_mcu7t5v0__fill_2
X_3405_ _4065_/Q _3398_/Z _4066_/Q _3406_/A3 VDD VDD VSS VSS gf180mcu_fd_sc_mcu7t5v0__aoi21_1
X_3336_ _4052_/Q _3333_/Z _3336_/Z VDD VDD VSS VSS gf180mcu_fd_sc_mcu7t5v0__and2_1
XPHY_EDGE_ROW_0_Left_122 VDD VSS gf180mcu_fd_sc_mcu7t5v0__endcap
XPHY_EDGE_ROW_37_Left_159 VDD VSS gf180mcu_fd_sc_mcu7t5v0__endcap
X_3267_ wire90/Z _3268_/A2 wire81/Z _3268_/B VDD VDD VSS VSS gf180mcu_fd_sc_mcu7t5v0__oai21_1
X_2218_ _3510_/A1 _2111_/Z _2218_/B _3793_/D VDD VDD VSS VSS gf180mcu_fd_sc_mcu7t5v0__aoi21_1
X_3198_ _3198_/A1 _3206_/A2 _3198_/B _3994_/D VDD VDD VSS VSS gf180mcu_fd_sc_mcu7t5v0__aoi21_1
X_2149_ hold222/Z _2155_/A2 _2151_/A1 VDD VDD VSS VSS gf180mcu_fd_sc_mcu7t5v0__nor2_1
XFILLER_38_195 VDD VDD VSS VSS gf180mcu_fd_sc_mcu7t5v0__fillcap_4
XFILLER_53_132 VDD VDD VSS VSS gf180mcu_fd_sc_mcu7t5v0__fillcap_8
XTAP_TAPCELL_ROW_108_898 VDD VSS gf180mcu_fd_sc_mcu7t5v0__filltie
XFILLER_121_36 VDD VDD VSS VSS gf180mcu_fd_sc_mcu7t5v0__fillcap_32
XFILLER_41_349 VDD VDD VSS VSS gf180mcu_fd_sc_mcu7t5v0__fill_1
XFILLER_53_198 VDD VDD VSS VSS gf180mcu_fd_sc_mcu7t5v0__fill_1
XFILLER_14_34 VDD VDD VSS VSS gf180mcu_fd_sc_mcu7t5v0__fill_1
XPHY_EDGE_ROW_46_Left_168 VDD VSS gf180mcu_fd_sc_mcu7t5v0__endcap
XFILLER_39_31 VDD VDD VSS VSS gf180mcu_fd_sc_mcu7t5v0__fill_1
XFILLER_39_42 VDD VDD VSS VSS gf180mcu_fd_sc_mcu7t5v0__fill_1
XPHY_EDGE_ROW_55_Left_177 VDD VSS gf180mcu_fd_sc_mcu7t5v0__endcap
XFILLER_17_302 VDD VDD VSS VSS gf180mcu_fd_sc_mcu7t5v0__fill_2
XFILLER_76_279 VDD VDD VSS VSS gf180mcu_fd_sc_mcu7t5v0__fill_2
XTAP_TAPCELL_ROW_87_775 VDD VSS gf180mcu_fd_sc_mcu7t5v0__filltie
XFILLER_91_216 VDD VDD VSS VSS gf180mcu_fd_sc_mcu7t5v0__fill_2
XFILLER_17_346 VDD VDD VSS VSS gf180mcu_fd_sc_mcu7t5v0__fillcap_4
XFILLER_91_238 VDD VDD VSS VSS gf180mcu_fd_sc_mcu7t5v0__fillcap_8
XPHY_EDGE_ROW_64_Left_186 VDD VSS gf180mcu_fd_sc_mcu7t5v0__endcap
XTAP_TAPCELL_ROW_70_675 VDD VSS gf180mcu_fd_sc_mcu7t5v0__filltie
XFILLER_71_84 VDD VDD VSS VSS gf180mcu_fd_sc_mcu7t5v0__fill_2
XPHY_EDGE_ROW_73_Left_195 VDD VSS gf180mcu_fd_sc_mcu7t5v0__endcap
XFILLER_99_338 VDD VDD VSS VSS gf180mcu_fd_sc_mcu7t5v0__fillcap_4
X_4170_ input2/Z _4170_/CLK _4170_/Q VDD VDD VSS VSS gf180mcu_fd_sc_mcu7t5v0__dffq_1
X_3121_ _3121_/A1 _3121_/A2 _3121_/B _3958_/D VDD VDD VSS VSS gf180mcu_fd_sc_mcu7t5v0__aoi21_1
XTAP_TAPCELL_ROW_78_720 VDD VSS gf180mcu_fd_sc_mcu7t5v0__filltie
XFILLER_55_419 VDD VDD VSS VSS gf180mcu_fd_sc_mcu7t5v0__fill_1
X_3052_ _3842_/Q _3052_/A2 _3840_/Q _3055_/B1 VDD VDD VSS VSS gf180mcu_fd_sc_mcu7t5v0__oai21_1
X_2003_ _3942_/Q _3087_/A1 VDD VDD VSS VSS gf180mcu_fd_sc_mcu7t5v0__clkinv_1
XFILLER_82_238 VDD VDD VSS VSS gf180mcu_fd_sc_mcu7t5v0__fillcap_4
XFILLER_23_305 VDD VDD VSS VSS gf180mcu_fd_sc_mcu7t5v0__fill_1
XFILLER_35_154 VDD VDD VSS VSS gf180mcu_fd_sc_mcu7t5v0__fillcap_4
XTAP_TAPCELL_ROW_18_363 VDD VSS gf180mcu_fd_sc_mcu7t5v0__filltie
XFILLER_35_176 VDD VDD VSS VSS gf180mcu_fd_sc_mcu7t5v0__fill_1
XTAP_TAPCELL_ROW_61_620 VDD VSS gf180mcu_fd_sc_mcu7t5v0__filltie
XFILLER_23_349 VDD VDD VSS VSS gf180mcu_fd_sc_mcu7t5v0__fill_1
X_3954_ _3954_/D _4162_/CLK _3954_/Q VDD VDD VSS VSS gf180mcu_fd_sc_mcu7t5v0__dffq_1
X_3885_ _3885_/D clkload1/I _3885_/Q VDD VDD VSS VSS gf180mcu_fd_sc_mcu7t5v0__dffq_1
X_2905_ _2760_/C _2904_/Z _3914_/D VDD VDD VSS VSS gf180mcu_fd_sc_mcu7t5v0__nor2_1
X_2836_ _3962_/Q _3904_/Q _2836_/B1 _2832_/Z _2836_/C _2837_/B VDD VDD VSS VSS gf180mcu_fd_sc_mcu7t5v0__aoi221_1
X_2767_ _2760_/C _2766_/Z _3895_/D VDD VDD VSS VSS gf180mcu_fd_sc_mcu7t5v0__nor2_1
X_2698_ _2698_/A1 _2698_/A2 _2698_/B _2699_/B VDD VDD VSS VSS gf180mcu_fd_sc_mcu7t5v0__oai21_1
XFILLER_104_115 VDD VDD VSS VSS gf180mcu_fd_sc_mcu7t5v0__fill_1
XFILLER_98_371 VDD VDD VSS VSS gf180mcu_fd_sc_mcu7t5v0__fill_2
X_3319_ _3395_/A1 _3319_/A2 _3318_/Z _4046_/D VDD VDD VSS VSS gf180mcu_fd_sc_mcu7t5v0__nor3_1
XFILLER_100_332 VDD VDD VSS VSS gf180mcu_fd_sc_mcu7t5v0__fillcap_16
XFILLER_100_387 VDD VDD VSS VSS gf180mcu_fd_sc_mcu7t5v0__fill_1
XTAP_TAPCELL_ROW_84_756 VDD VSS gf180mcu_fd_sc_mcu7t5v0__filltie
XFILLER_81_282 VDD VDD VSS VSS gf180mcu_fd_sc_mcu7t5v0__fillcap_8
XFILLER_41_146 VDD VDD VSS VSS gf180mcu_fd_sc_mcu7t5v0__fill_1
XTAP_TAPCELL_ROW_24_399 VDD VSS gf180mcu_fd_sc_mcu7t5v0__filltie
XFILLER_110_107 VDD VDD VSS VSS gf180mcu_fd_sc_mcu7t5v0__fillcap_4
XTAP_TAPCELL_ROW_75_701 VDD VSS gf180mcu_fd_sc_mcu7t5v0__filltie
XFILLER_17_176 VDD VDD VSS VSS gf180mcu_fd_sc_mcu7t5v0__fillcap_4
XTAP_TAPCELL_ROW_15_344 VDD VSS gf180mcu_fd_sc_mcu7t5v0__filltie
X_3670_ _3731_/C _3670_/A2 _4121_/D VDD VDD VSS VSS gf180mcu_fd_sc_mcu7t5v0__nor2_1
X_2621_ _2621_/A1 _2621_/A2 _2621_/B _2622_/A2 VDD VDD VSS VSS gf180mcu_fd_sc_mcu7t5v0__aoi21_1
X_2552_ _2552_/A1 _4157_/Q _2555_/B1 _2552_/B1 _2555_/A3 _3879_/D VDD VDD VSS VSS
+ gf180mcu_fd_sc_mcu7t5v0__oai32_1
XPHY_EDGE_ROW_81_Left_203 VDD VSS gf180mcu_fd_sc_mcu7t5v0__endcap
X_2483_ _3811_/Q _2495_/A2 _2495_/B1 _3859_/Q _2495_/C _2485_/A1 VDD VDD VSS VSS gf180mcu_fd_sc_mcu7t5v0__oai221_1
X_4153_ _4153_/D _4155_/CLK _4198_/I VDD VDD VSS VSS gf180mcu_fd_sc_mcu7t5v0__dffq_1
X_3104_ _3104_/A1 _3104_/A2 _3104_/B _3950_/D VDD VDD VSS VSS gf180mcu_fd_sc_mcu7t5v0__aoi21_1
X_4084_ _4084_/D clkload4/I _4084_/Q VDD VDD VSS VSS gf180mcu_fd_sc_mcu7t5v0__dffq_1
XFILLER_95_352 VDD VDD VSS VSS gf180mcu_fd_sc_mcu7t5v0__fillcap_4
XTAP_TAPCELL_ROW_118_960 VDD VSS gf180mcu_fd_sc_mcu7t5v0__filltie
XFILLER_55_227 VDD VDD VSS VSS gf180mcu_fd_sc_mcu7t5v0__fill_2
X_3035_ _3942_/Q _3083_/A1 _3045_/A1 VDD VDD VSS VSS gf180mcu_fd_sc_mcu7t5v0__nand2_1
XPHY_EDGE_ROW_90_Left_212 VDD VSS gf180mcu_fd_sc_mcu7t5v0__endcap
XFILLER_51_422 VDD VDD VSS VSS gf180mcu_fd_sc_mcu7t5v0__fillcap_4
XTAP_TAPCELL_ROW_81_737 VDD VSS gf180mcu_fd_sc_mcu7t5v0__filltie
XFILLER_102_49 VDD VDD VSS VSS gf180mcu_fd_sc_mcu7t5v0__fill_1
XFILLER_23_135 VDD VDD VSS VSS gf180mcu_fd_sc_mcu7t5v0__fillcap_4
X_3937_ _3937_/D _4170_/CLK _3937_/Q VDD VDD VSS VSS gf180mcu_fd_sc_mcu7t5v0__dffq_1
XFILLER_11_319 VDD VDD VSS VSS gf180mcu_fd_sc_mcu7t5v0__fillcap_4
XTAP_TAPCELL_ROW_101_860 VDD VSS gf180mcu_fd_sc_mcu7t5v0__filltie
X_3868_ _3868_/D clkload7/I _3868_/Q VDD VDD VSS VSS gf180mcu_fd_sc_mcu7t5v0__dffq_1
X_2819_ _2819_/A1 _2814_/Z _2819_/Z VDD VDD VSS VSS gf180mcu_fd_sc_mcu7t5v0__or2_1
X_3799_ _3799_/D clkload3/I _3799_/Q VDD VDD VSS VSS gf180mcu_fd_sc_mcu7t5v0__dffq_1
XFILLER_105_413 VDD VDD VSS VSS gf180mcu_fd_sc_mcu7t5v0__fillcap_4
XTAP_TAPCELL_ROW_29_425 VDD VSS gf180mcu_fd_sc_mcu7t5v0__filltie
XFILLER_100_173 VDD VDD VSS VSS gf180mcu_fd_sc_mcu7t5v0__fill_2
XFILLER_14_102 VDD VDD VSS VSS gf180mcu_fd_sc_mcu7t5v0__fill_2
XFILLER_36_87 VDD VDD VSS VSS gf180mcu_fd_sc_mcu7t5v0__fill_1
XTAP_TAPCELL_ROW_12_325 VDD VSS gf180mcu_fd_sc_mcu7t5v0__filltie
Xclkbuf_leaf_17_ext_clk_in clkbuf_leaf_1_ext_clk_in/I clkload7/I VDD VDD VSS VSS gf180mcu_fd_sc_mcu7t5v0__clkbuf_8
XFILLER_77_72 VDD VDD VSS VSS gf180mcu_fd_sc_mcu7t5v0__fill_2
XFILLER_37_205 VDD VDD VSS VSS gf180mcu_fd_sc_mcu7t5v0__fill_1
XTAP_TAPCELL_ROW_115_941 VDD VSS gf180mcu_fd_sc_mcu7t5v0__filltie
XFILLER_33_422 VDD VDD VSS VSS gf180mcu_fd_sc_mcu7t5v0__fillcap_4
X_1983_ _3962_/Q _3130_/A1 VDD VDD VSS VSS gf180mcu_fd_sc_mcu7t5v0__clkinv_1
XFILLER_9_150 VDD VDD VSS VSS gf180mcu_fd_sc_mcu7t5v0__fill_2
X_3722_ _3587_/B _3723_/A2 _3729_/A2 VDD VDD VSS VSS gf180mcu_fd_sc_mcu7t5v0__nand2_1
X_3653_ _3788_/Q _3663_/A2 _3663_/B1 _3772_/Q _3655_/A2 VDD VDD VSS VSS gf180mcu_fd_sc_mcu7t5v0__aoi22_1
X_2604_ _4006_/Q _2915_/A2 _2651_/A2 _4005_/Q _2607_/B VDD VDD VSS VSS gf180mcu_fd_sc_mcu7t5v0__oai22_1
X_3584_ _4113_/Q _3584_/A2 _3585_/A2 VDD VDD VSS VSS gf180mcu_fd_sc_mcu7t5v0__xnor2_1
X_2535_ _2510_/B _2534_/Z _3875_/Q _2536_/B2 VDD VDD VSS VSS gf180mcu_fd_sc_mcu7t5v0__aoi21_1
X_2466_ _4114_/Q _3925_/Q _2466_/Z VDD VDD VSS VSS gf180mcu_fd_sc_mcu7t5v0__or2_1
X_2397_ _2397_/I _3842_/D VDD VDD VSS VSS gf180mcu_fd_sc_mcu7t5v0__clkinv_1
X_4136_ _4136_/D _4155_/CLK _4136_/Q VDD VDD VSS VSS gf180mcu_fd_sc_mcu7t5v0__dffq_1
X_4067_ _4067_/D _4073_/CLK _4067_/Q VDD VDD VSS VSS gf180mcu_fd_sc_mcu7t5v0__dffq_1
XTAP_TAPCELL_ROW_26_406 VDD VSS gf180mcu_fd_sc_mcu7t5v0__filltie
XFILLER_43_208 VDD VDD VSS VSS gf180mcu_fd_sc_mcu7t5v0__fill_2
X_3018_ hold147/Z _3018_/A2 _3018_/B1 _3018_/B2 _3019_/A2 VDD VDD VSS VSS gf180mcu_fd_sc_mcu7t5v0__aoi22_1
Xwire31 wire31/I wire31/Z VDD VDD VSS VSS gf180mcu_fd_sc_mcu7t5v0__buf_2
XFILLER_36_282 VDD VDD VSS VSS gf180mcu_fd_sc_mcu7t5v0__fillcap_4
XTAP_TAPCELL_ROW_121_977 VDD VSS gf180mcu_fd_sc_mcu7t5v0__filltie
XFILLER_105_232 VDD VDD VSS VSS gf180mcu_fd_sc_mcu7t5v0__fill_2
XFILLER_105_265 VDD VDD VSS VSS gf180mcu_fd_sc_mcu7t5v0__fillcap_4
XPHY_EDGE_ROW_110_Right_110 VDD VSS gf180mcu_fd_sc_mcu7t5v0__endcap
XFILLER_59_352 VDD VDD VSS VSS gf180mcu_fd_sc_mcu7t5v0__fillcap_4
XFILLER_86_171 VDD VDD VSS VSS gf180mcu_fd_sc_mcu7t5v0__fillcap_4
XFILLER_19_249 VDD VDD VSS VSS gf180mcu_fd_sc_mcu7t5v0__fillcap_4
XTAP_TAPCELL_ROW_112_922 VDD VSS gf180mcu_fd_sc_mcu7t5v0__filltie
XFILLER_27_293 VDD VDD VSS VSS gf180mcu_fd_sc_mcu7t5v0__fill_2
XFILLER_15_422 VDD VDD VSS VSS gf180mcu_fd_sc_mcu7t5v0__fillcap_4
XTAP_TAPCELL_ROW_57_597 VDD VSS gf180mcu_fd_sc_mcu7t5v0__filltie
XFILLER_30_425 VDD VDD VSS VSS gf180mcu_fd_sc_mcu7t5v0__fill_1
XFILLER_10_160 VDD VDD VSS VSS gf180mcu_fd_sc_mcu7t5v0__fillcap_4
XFILLER_8_69 VDD VDD VSS VSS gf180mcu_fd_sc_mcu7t5v0__fill_1
X_2320_ _4163_/Q _2333_/B _2332_/A2 _2320_/B _2321_/I1 VDD VDD VSS VSS gf180mcu_fd_sc_mcu7t5v0__oai31_1
XFILLER_88_71 VDD VDD VSS VSS gf180mcu_fd_sc_mcu7t5v0__fill_1
XFILLER_97_414 VDD VDD VSS VSS gf180mcu_fd_sc_mcu7t5v0__fillcap_4
X_2251_ _3824_/Q _2360_/A1 _2257_/A3 VDD VDD VSS VSS gf180mcu_fd_sc_mcu7t5v0__nand2_1
XFILLER_2_381 VDD VDD VSS VSS gf180mcu_fd_sc_mcu7t5v0__fillcap_4
XFILLER_69_127 VDD VDD VSS VSS gf180mcu_fd_sc_mcu7t5v0__fillcap_8
XFILLER_88_93 VDD VDD VSS VSS gf180mcu_fd_sc_mcu7t5v0__fillcap_8
X_2182_ hold194/Z _2242_/A2 _2184_/A1 VDD VDD VSS VSS gf180mcu_fd_sc_mcu7t5v0__nor2_1
XTAP_TAPCELL_ROW_48_542 VDD VSS gf180mcu_fd_sc_mcu7t5v0__filltie
XFILLER_80_314 VDD VDD VSS VSS gf180mcu_fd_sc_mcu7t5v0__fill_1
XFILLER_18_271 VDD VDD VSS VSS gf180mcu_fd_sc_mcu7t5v0__fillcap_4
XFILLER_33_263 VDD VDD VSS VSS gf180mcu_fd_sc_mcu7t5v0__fill_1
X_1966_ _3979_/Q _3166_/A1 VDD VDD VSS VSS gf180mcu_fd_sc_mcu7t5v0__clkinv_1
XFILLER_119_335 VDD VDD VSS VSS gf180mcu_fd_sc_mcu7t5v0__fill_1
X_3705_ _3705_/A1 _3699_/Z _3705_/B wire81/Z _4133_/D VDD VDD VSS VSS gf180mcu_fd_sc_mcu7t5v0__oai211_1
X_1897_ _4077_/Q _3384_/A2 VDD VDD VSS VSS gf180mcu_fd_sc_mcu7t5v0__clkinv_1
X_3636_ _3778_/Q _3662_/B1 _3663_/B1 _3770_/Q _3636_/C _3639_/A2 VDD VDD VSS VSS gf180mcu_fd_sc_mcu7t5v0__aoi221_1
XFILLER_108_26 VDD VDD VSS VSS gf180mcu_fd_sc_mcu7t5v0__fill_1
X_3567_ _3579_/B _3567_/A2 _3567_/A3 _4108_/D VDD VDD VSS VSS gf180mcu_fd_sc_mcu7t5v0__nor3_1
XFILLER_108_59 VDD VDD VSS VSS gf180mcu_fd_sc_mcu7t5v0__fill_2
XFILLER_108_37 VDD VDD VSS VSS gf180mcu_fd_sc_mcu7t5v0__fillcap_8
X_2518_ _2546_/B _2518_/A2 _2521_/B1 VDD VDD VSS VSS gf180mcu_fd_sc_mcu7t5v0__nand2_1
X_3498_ _4088_/Q _3498_/A2 _3536_/A2 _3497_/Z _3499_/A2 VDD VDD VSS VSS gf180mcu_fd_sc_mcu7t5v0__aoi22_1
X_2449_ _2449_/A1 _2449_/A2 _3861_/D VDD VDD VSS VSS gf180mcu_fd_sc_mcu7t5v0__nor2_1
XFILLER_68_193 VDD VDD VSS VSS gf180mcu_fd_sc_mcu7t5v0__fillcap_4
X_4119_ _4119_/D _4149_/CLK _4119_/Q VDD VDD VSS VSS gf180mcu_fd_sc_mcu7t5v0__dffq_1
XFILLER_71_314 VDD VDD VSS VSS gf180mcu_fd_sc_mcu7t5v0__fill_2
XFILLER_83_152 VDD VDD VSS VSS gf180mcu_fd_sc_mcu7t5v0__fillcap_4
XTAP_TAPCELL_ROW_54_578 VDD VSS gf180mcu_fd_sc_mcu7t5v0__filltie
XFILLER_24_274 VDD VDD VSS VSS gf180mcu_fd_sc_mcu7t5v0__fillcap_32
XFILLER_12_425 VDD VDD VSS VSS gf180mcu_fd_sc_mcu7t5v0__fill_1
XFILLER_116_2 VDD VDD VSS VSS gf180mcu_fd_sc_mcu7t5v0__fill_2
XTAP_TAPCELL_ROW_45_523 VDD VSS gf180mcu_fd_sc_mcu7t5v0__filltie
Xclkbuf_leaf_7_ext_clk_in clkload0/I _4149_/CLK VDD VDD VSS VSS gf180mcu_fd_sc_mcu7t5v0__clkbuf_8
XFILLER_30_244 VDD VDD VSS VSS gf180mcu_fd_sc_mcu7t5v0__fill_1
X_3421_ _4072_/Q _3418_/Z _3421_/B _4072_/D VDD VDD VSS VSS gf180mcu_fd_sc_mcu7t5v0__aoi21_1
X_3352_ _3363_/B _3352_/A2 _3351_/Z _4057_/D VDD VDD VSS VSS gf180mcu_fd_sc_mcu7t5v0__nor3_1
X_2303_ _3812_/Q _2300_/S _2304_/B VDD VDD VSS VSS gf180mcu_fd_sc_mcu7t5v0__nand2_1
X_3283_ _3283_/A1 _3283_/A2 _3283_/B _4034_/D VDD VDD VSS VSS gf180mcu_fd_sc_mcu7t5v0__aoi21_1
X_2234_ _2234_/A1 _2234_/A2 _3799_/D VDD VDD VSS VSS gf180mcu_fd_sc_mcu7t5v0__nor2_1
XTAP_TAPCELL_ROW_68_659 VDD VSS gf180mcu_fd_sc_mcu7t5v0__filltie
X_2165_ _3775_/Q _2243_/A2 _3746_/B _2166_/A2 VDD VDD VSS VSS gf180mcu_fd_sc_mcu7t5v0__oai21_1
XFILLER_0_70 VDD VDD VSS VSS gf180mcu_fd_sc_mcu7t5v0__fillcap_32
X_2096_ _3840_/Q _3839_/Q _2097_/A2 VDD VDD VSS VSS gf180mcu_fd_sc_mcu7t5v0__nand2_1
XFILLER_80_177 VDD VDD VSS VSS gf180mcu_fd_sc_mcu7t5v0__fill_2
XFILLER_21_222 VDD VDD VSS VSS gf180mcu_fd_sc_mcu7t5v0__fill_2
XTAP_TAPCELL_ROW_51_559 VDD VSS gf180mcu_fd_sc_mcu7t5v0__filltie
X_2998_ _2998_/A1 _2998_/A2 _2997_/Z _2999_/B2 VDD VDD VSS VSS gf180mcu_fd_sc_mcu7t5v0__nand3_1
XFILLER_119_132 VDD VDD VSS VSS gf180mcu_fd_sc_mcu7t5v0__fillcap_8
X_1949_ _3996_/Q _3202_/A1 VDD VDD VSS VSS gf180mcu_fd_sc_mcu7t5v0__clkinv_1
XFILLER_119_69 VDD VDD VSS VSS gf180mcu_fd_sc_mcu7t5v0__fill_1
XFILLER_119_58 VDD VDD VSS VSS gf180mcu_fd_sc_mcu7t5v0__fill_2
XFILLER_79_18 VDD VDD VSS VSS gf180mcu_fd_sc_mcu7t5v0__fill_2
X_3619_ _4195_/I _3629_/C2 _3723_/A2 _4144_/Q _3621_/A1 VDD VDD VSS VSS gf180mcu_fd_sc_mcu7t5v0__aoi22_1
XFILLER_115_360 VDD VDD VSS VSS gf180mcu_fd_sc_mcu7t5v0__fillcap_4
XFILLER_0_104 VDD VDD VSS VSS gf180mcu_fd_sc_mcu7t5v0__fillcap_32
XTAP_TAPCELL_ROW_59_604 VDD VSS gf180mcu_fd_sc_mcu7t5v0__filltie
XFILLER_28_22 VDD VDD VSS VSS gf180mcu_fd_sc_mcu7t5v0__fill_2
XFILLER_28_33 VDD VDD VSS VSS gf180mcu_fd_sc_mcu7t5v0__fill_2
XFILLER_56_130 VDD VDD VSS VSS gf180mcu_fd_sc_mcu7t5v0__fillcap_8
XFILLER_28_99 VDD VDD VSS VSS gf180mcu_fd_sc_mcu7t5v0__fillcap_4
XFILLER_44_32 VDD VDD VSS VSS gf180mcu_fd_sc_mcu7t5v0__fill_2
XTAP_TAPCELL_ROW_42_504 VDD VSS gf180mcu_fd_sc_mcu7t5v0__filltie
XFILLER_106_360 VDD VDD VSS VSS gf180mcu_fd_sc_mcu7t5v0__fillcap_4
XFILLER_69_51 VDD VDD VSS VSS gf180mcu_fd_sc_mcu7t5v0__fill_1
XFILLER_79_233 VDD VDD VSS VSS gf180mcu_fd_sc_mcu7t5v0__fill_1
XFILLER_106_382 VDD VDD VSS VSS gf180mcu_fd_sc_mcu7t5v0__fill_2
XTAP_TAPCELL_ROW_7_292 VDD VSS gf180mcu_fd_sc_mcu7t5v0__filltie
XFILLER_94_214 VDD VDD VSS VSS gf180mcu_fd_sc_mcu7t5v0__fillcap_16
XPHY_EDGE_ROW_13_Right_13 VDD VSS gf180mcu_fd_sc_mcu7t5v0__endcap
X_3970_ _3970_/D _4034_/CLK _3970_/Q VDD VDD VSS VSS gf180mcu_fd_sc_mcu7t5v0__dffq_1
XFILLER_62_177 VDD VDD VSS VSS gf180mcu_fd_sc_mcu7t5v0__fill_2
X_2921_ _2760_/C _2921_/A2 _2920_/Z _3916_/D VDD VDD VSS VSS gf180mcu_fd_sc_mcu7t5v0__nor3_1
X_2852_ _2848_/Z _2858_/A2 _2852_/Z VDD VDD VSS VSS gf180mcu_fd_sc_mcu7t5v0__and2_1
Xclkbuf_1_0__f__1526_ clkbuf_0__1526_/Z _3528_/A3 VDD VDD VSS VSS gf180mcu_fd_sc_mcu7t5v0__clkbuf_16
XPHY_EDGE_ROW_22_Right_22 VDD VSS gf180mcu_fd_sc_mcu7t5v0__endcap
X_2783_ _3956_/Q _3898_/Q _2798_/A2 VDD VDD VSS VSS gf180mcu_fd_sc_mcu7t5v0__xnor2_1
Xhold226 _4009_/Q _1936_/I VDD VDD VSS VSS gf180mcu_fd_sc_mcu7t5v0__dlyc_1
Xhold204 _4120_/Q hold204/Z VDD VDD VSS VSS gf180mcu_fd_sc_mcu7t5v0__dlyc_1
Xhold215 _4115_/Q hold215/Z VDD VDD VSS VSS gf180mcu_fd_sc_mcu7t5v0__dlyc_1
X_3404_ _4066_/Q _4065_/Q _3398_/Z _3404_/Z VDD VDD VSS VSS gf180mcu_fd_sc_mcu7t5v0__and3_1
X_3335_ _4052_/Q _3333_/Z _3337_/A2 VDD VDD VSS VSS gf180mcu_fd_sc_mcu7t5v0__nor2_1
XFILLER_112_363 VDD VDD VSS VSS gf180mcu_fd_sc_mcu7t5v0__fillcap_4
XPHY_EDGE_ROW_31_Right_31 VDD VSS gf180mcu_fd_sc_mcu7t5v0__endcap
X_3266_ _3266_/A1 _3274_/A2 _3266_/B _4026_/D VDD VDD VSS VSS gf180mcu_fd_sc_mcu7t5v0__aoi21_1
X_2217_ _3793_/Q _2111_/Z _3746_/B _2218_/B VDD VDD VSS VSS gf180mcu_fd_sc_mcu7t5v0__oai21_1
XFILLER_38_163 VDD VDD VSS VSS gf180mcu_fd_sc_mcu7t5v0__fillcap_8
X_3197_ wire91/Z _3206_/A2 wire81/Z _3198_/B VDD VDD VSS VSS gf180mcu_fd_sc_mcu7t5v0__oai21_1
X_2148_ _2148_/A1 _2148_/A2 hold201/I VDD VDD VSS VSS gf180mcu_fd_sc_mcu7t5v0__nor2_1
X_2079_ _2376_/A1 hold124/Z _4159_/D VDD VDD VSS VSS gf180mcu_fd_sc_mcu7t5v0__and2_1
XTAP_TAPCELL_ROW_108_899 VDD VSS gf180mcu_fd_sc_mcu7t5v0__filltie
XPHY_EDGE_ROW_40_Right_40 VDD VSS gf180mcu_fd_sc_mcu7t5v0__endcap
XPHY_EDGE_ROW_101_Left_223 VDD VSS gf180mcu_fd_sc_mcu7t5v0__endcap
XFILLER_14_79 VDD VDD VSS VSS gf180mcu_fd_sc_mcu7t5v0__fill_2
XPHY_EDGE_ROW_110_Left_232 VDD VSS gf180mcu_fd_sc_mcu7t5v0__endcap
XFILLER_49_417 VDD VDD VSS VSS gf180mcu_fd_sc_mcu7t5v0__fill_2
XFILLER_103_385 VDD VDD VSS VSS gf180mcu_fd_sc_mcu7t5v0__fill_1
XFILLER_29_130 VDD VDD VSS VSS gf180mcu_fd_sc_mcu7t5v0__fill_2
XTAP_TAPCELL_ROW_87_776 VDD VSS gf180mcu_fd_sc_mcu7t5v0__filltie
XFILLER_32_317 VDD VDD VSS VSS gf180mcu_fd_sc_mcu7t5v0__fillcap_4
XFILLER_44_177 VDD VDD VSS VSS gf180mcu_fd_sc_mcu7t5v0__fillcap_16
XFILLER_40_383 VDD VDD VSS VSS gf180mcu_fd_sc_mcu7t5v0__fill_2
XFILLER_65_8 VDD VDD VSS VSS gf180mcu_fd_sc_mcu7t5v0__fill_1
X_3120_ _3290_/A1 _3121_/A2 _3256_/B _3121_/B VDD VDD VSS VSS gf180mcu_fd_sc_mcu7t5v0__oai21_1
XTAP_TAPCELL_ROW_78_721 VDD VSS gf180mcu_fd_sc_mcu7t5v0__filltie
X_3051_ _3667_/C2 _3839_/Q _2943_/Z _3841_/Q _3052_/A2 VDD VDD VSS VSS gf180mcu_fd_sc_mcu7t5v0__oai31_1
X_2002_ _3943_/Q _3090_/A1 VDD VDD VSS VSS gf180mcu_fd_sc_mcu7t5v0__clkinv_1
XFILLER_50_103 VDD VDD VSS VSS gf180mcu_fd_sc_mcu7t5v0__fill_2
XFILLER_90_272 VDD VDD VSS VSS gf180mcu_fd_sc_mcu7t5v0__fill_1
X_3953_ _3953_/D clkload9/I _3953_/Q VDD VDD VSS VSS gf180mcu_fd_sc_mcu7t5v0__dffq_1
XFILLER_35_199 VDD VDD VSS VSS gf180mcu_fd_sc_mcu7t5v0__fill_2
XTAP_TAPCELL_ROW_61_621 VDD VSS gf180mcu_fd_sc_mcu7t5v0__filltie
X_3884_ _3884_/D clkload5/I _3884_/Q VDD VDD VSS VSS gf180mcu_fd_sc_mcu7t5v0__dffq_1
XFILLER_31_361 VDD VDD VSS VSS gf180mcu_fd_sc_mcu7t5v0__fill_2
X_2904_ _2902_/Z _2904_/A2 _2904_/Z VDD VDD VSS VSS gf180mcu_fd_sc_mcu7t5v0__xor2_1
X_2835_ _2835_/I _2836_/C VDD VDD VSS VSS gf180mcu_fd_sc_mcu7t5v0__clkinv_1
XFILLER_117_422 VDD VDD VSS VSS gf180mcu_fd_sc_mcu7t5v0__fillcap_4
X_2766_ _2762_/I _2766_/A2 _2766_/Z VDD VDD VSS VSS gf180mcu_fd_sc_mcu7t5v0__xor2_1
X_2697_ _2651_/B _2697_/A2 _2698_/B VDD VDD VSS VSS gf180mcu_fd_sc_mcu7t5v0__nand2_1
X_3318_ _4046_/Q _3315_/Z _3318_/Z VDD VDD VSS VSS gf180mcu_fd_sc_mcu7t5v0__and2_1
XFILLER_98_383 VDD VDD VSS VSS gf180mcu_fd_sc_mcu7t5v0__fill_2
XFILLER_112_193 VDD VDD VSS VSS gf180mcu_fd_sc_mcu7t5v0__fillcap_4
XFILLER_58_236 VDD VDD VSS VSS gf180mcu_fd_sc_mcu7t5v0__fill_1
XFILLER_58_247 VDD VDD VSS VSS gf180mcu_fd_sc_mcu7t5v0__fill_2
X_3249_ _3249_/A1 _3257_/A2 _3249_/B _4018_/D VDD VDD VSS VSS gf180mcu_fd_sc_mcu7t5v0__aoi21_1
XFILLER_54_420 VDD VDD VSS VSS gf180mcu_fd_sc_mcu7t5v0__fillcap_4
XFILLER_26_144 VDD VDD VSS VSS gf180mcu_fd_sc_mcu7t5v0__fill_2
XTAP_TAPCELL_ROW_84_757 VDD VSS gf180mcu_fd_sc_mcu7t5v0__filltie
XFILLER_26_188 VDD VDD VSS VSS gf180mcu_fd_sc_mcu7t5v0__fillcap_8
XFILLER_14_306 VDD VDD VSS VSS gf180mcu_fd_sc_mcu7t5v0__fill_1
XFILLER_22_383 VDD VDD VSS VSS gf180mcu_fd_sc_mcu7t5v0__fill_2
XFILLER_9_2 VDD VDD VSS VSS gf180mcu_fd_sc_mcu7t5v0__fillcap_8
XFILLER_110_119 VDD VDD VSS VSS gf180mcu_fd_sc_mcu7t5v0__fillcap_8
XFILLER_89_372 VDD VDD VSS VSS gf180mcu_fd_sc_mcu7t5v0__fill_2
XTAP_TAPCELL_ROW_75_702 VDD VSS gf180mcu_fd_sc_mcu7t5v0__filltie
XFILLER_60_423 VDD VDD VSS VSS gf180mcu_fd_sc_mcu7t5v0__fill_2
XFILLER_82_73 VDD VDD VSS VSS gf180mcu_fd_sc_mcu7t5v0__fill_1
XTAP_TAPCELL_ROW_15_345 VDD VSS gf180mcu_fd_sc_mcu7t5v0__filltie
X_2620_ _2620_/A1 _2620_/A2 _2620_/B _2621_/A2 VDD VDD VSS VSS gf180mcu_fd_sc_mcu7t5v0__oai21_1
X_2551_ _2428_/B _2427_/Z _2465_/B _2552_/B1 VDD VDD VSS VSS gf180mcu_fd_sc_mcu7t5v0__nand3_1
XFILLER_114_414 VDD VDD VSS VSS gf180mcu_fd_sc_mcu7t5v0__fillcap_8
X_2482_ _2482_/I0 hold216/Z _2482_/S _3866_/D VDD VDD VSS VSS gf180mcu_fd_sc_mcu7t5v0__mux2_2
XFILLER_87_309 VDD VDD VSS VSS gf180mcu_fd_sc_mcu7t5v0__fill_1
XTAP_TAPCELL_ROW_98_838 VDD VSS gf180mcu_fd_sc_mcu7t5v0__filltie
X_4152_ _4152_/D _4155_/CLK _4197_/I VDD VDD VSS VSS gf180mcu_fd_sc_mcu7t5v0__dffq_1
X_3103_ _3290_/A1 _3104_/A2 wire81/I _3104_/B VDD VDD VSS VSS gf180mcu_fd_sc_mcu7t5v0__oai21_1
X_4083_ _4083_/D _4104_/CLK _4083_/Q VDD VDD VSS VSS gf180mcu_fd_sc_mcu7t5v0__dffq_1
XTAP_TAPCELL_ROW_118_961 VDD VSS gf180mcu_fd_sc_mcu7t5v0__filltie
X_3034_ _3731_/C _3034_/A2 _3925_/D VDD VDD VSS VSS gf180mcu_fd_sc_mcu7t5v0__nor2_1
XTAP_TAPCELL_ROW_81_738 VDD VSS gf180mcu_fd_sc_mcu7t5v0__filltie
X_3936_ _3936_/D _4169_/CLK _3936_/Q VDD VDD VSS VSS gf180mcu_fd_sc_mcu7t5v0__dffq_1
XTAP_TAPCELL_ROW_101_861 VDD VSS gf180mcu_fd_sc_mcu7t5v0__filltie
X_3867_ _3867_/D clkload2/I _3867_/Q VDD VDD VSS VSS gf180mcu_fd_sc_mcu7t5v0__dffq_1
X_2818_ _3961_/Q _3903_/Q _2823_/B VDD VDD VSS VSS gf180mcu_fd_sc_mcu7t5v0__xor2_1
X_3798_ _3798_/D clkload3/I _3798_/Q VDD VDD VSS VSS gf180mcu_fd_sc_mcu7t5v0__dffq_1
X_2749_ _2749_/A1 _2749_/A2 _2749_/A3 _2749_/B _2750_/A3 VDD VDD VSS VSS gf180mcu_fd_sc_mcu7t5v0__oai31_1
XFILLER_11_69 VDD VDD VSS VSS gf180mcu_fd_sc_mcu7t5v0__fill_1
XFILLER_86_375 VDD VDD VSS VSS gf180mcu_fd_sc_mcu7t5v0__fillcap_4
XTAP_TAPCELL_ROW_29_426 VDD VSS gf180mcu_fd_sc_mcu7t5v0__filltie
XFILLER_100_185 VDD VDD VSS VSS gf180mcu_fd_sc_mcu7t5v0__fillcap_4
XTAP_TAPCELL_ROW_12_326 VDD VSS gf180mcu_fd_sc_mcu7t5v0__filltie
XTAP_TAPCELL_ROW_20_370 VDD VSS gf180mcu_fd_sc_mcu7t5v0__filltie
XFILLER_77_51 VDD VDD VSS VSS gf180mcu_fd_sc_mcu7t5v0__fill_2
XFILLER_96_139 VDD VDD VSS VSS gf180mcu_fd_sc_mcu7t5v0__fillcap_4
XFILLER_77_84 VDD VDD VSS VSS gf180mcu_fd_sc_mcu7t5v0__fill_1
XFILLER_92_301 VDD VDD VSS VSS gf180mcu_fd_sc_mcu7t5v0__fillcap_8
XTAP_TAPCELL_ROW_115_942 VDD VSS gf180mcu_fd_sc_mcu7t5v0__filltie
X_1982_ _3963_/Q _3132_/A1 VDD VDD VSS VSS gf180mcu_fd_sc_mcu7t5v0__clkinv_1
X_3721_ _3721_/A1 _3721_/A2 _3729_/B VDD VDD VSS VSS gf180mcu_fd_sc_mcu7t5v0__nor2_1
X_3652_ _3764_/Q _3662_/A2 _3662_/B1 _3780_/Q _3655_/A1 VDD VDD VSS VSS gf180mcu_fd_sc_mcu7t5v0__aoi22_1
X_3583_ _3583_/A1 _3583_/A2 _3584_/A2 VDD VDD VSS VSS gf180mcu_fd_sc_mcu7t5v0__nor2_1
X_2603_ _2603_/A1 _2603_/A2 _2603_/B _2619_/A2 VDD VDD VSS VSS gf180mcu_fd_sc_mcu7t5v0__aoi21_1
XFILLER_114_211 VDD VDD VSS VSS gf180mcu_fd_sc_mcu7t5v0__fillcap_16
X_2534_ _2549_/A2 _2529_/Z _2534_/Z VDD VDD VSS VSS gf180mcu_fd_sc_mcu7t5v0__and2_1
XFILLER_114_244 VDD VDD VSS VSS gf180mcu_fd_sc_mcu7t5v0__fill_1
X_2465_ _2465_/A1 _2465_/A2 _2465_/B _2482_/S VDD VDD VSS VSS gf180mcu_fd_sc_mcu7t5v0__oai21_1
X_2396_ _3876_/Q _2396_/A2 _2400_/B1 _3842_/Q _2397_/I VDD VDD VSS VSS gf180mcu_fd_sc_mcu7t5v0__aoi22_1
XFILLER_87_139 VDD VDD VSS VSS gf180mcu_fd_sc_mcu7t5v0__fill_1
X_4135_ _4135_/D _4164_/CLK _4135_/Q VDD VDD VSS VSS gf180mcu_fd_sc_mcu7t5v0__dffq_1
XFILLER_113_16 VDD VDD VSS VSS gf180mcu_fd_sc_mcu7t5v0__fill_1
X_4066_ _4066_/D _4073_/CLK _4066_/Q VDD VDD VSS VSS gf180mcu_fd_sc_mcu7t5v0__dffq_1
XTAP_TAPCELL_ROW_26_407 VDD VSS gf180mcu_fd_sc_mcu7t5v0__filltie
X_3017_ _3017_/A1 _3017_/A2 _3016_/Z _3018_/B2 VDD VDD VSS VSS gf180mcu_fd_sc_mcu7t5v0__nand3_1
XFILLER_24_423 VDD VDD VSS VSS gf180mcu_fd_sc_mcu7t5v0__fill_2
XFILLER_51_231 VDD VDD VSS VSS gf180mcu_fd_sc_mcu7t5v0__fillcap_4
XTAP_TAPCELL_ROW_121_978 VDD VSS gf180mcu_fd_sc_mcu7t5v0__filltie
XFILLER_51_275 VDD VDD VSS VSS gf180mcu_fd_sc_mcu7t5v0__fill_1
X_3919_ _3919_/D clkload2/I _3919_/Q VDD VDD VSS VSS gf180mcu_fd_sc_mcu7t5v0__dffq_1
XFILLER_3_349 VDD VDD VSS VSS gf180mcu_fd_sc_mcu7t5v0__fill_1
XFILLER_120_247 VDD VDD VSS VSS gf180mcu_fd_sc_mcu7t5v0__fillcap_64
XFILLER_74_301 VDD VDD VSS VSS gf180mcu_fd_sc_mcu7t5v0__fill_1
XFILLER_74_312 VDD VDD VSS VSS gf180mcu_fd_sc_mcu7t5v0__fill_2
XFILLER_86_183 VDD VDD VSS VSS gf180mcu_fd_sc_mcu7t5v0__fill_1
XFILLER_103_82 VDD VDD VSS VSS gf180mcu_fd_sc_mcu7t5v0__fill_1
XTAP_TAPCELL_ROW_112_923 VDD VSS gf180mcu_fd_sc_mcu7t5v0__filltie
XPHY_EDGE_ROW_69_Right_69 VDD VSS gf180mcu_fd_sc_mcu7t5v0__endcap
XFILLER_63_97 VDD VDD VSS VSS gf180mcu_fd_sc_mcu7t5v0__fill_2
XFILLER_8_37 VDD VDD VSS VSS gf180mcu_fd_sc_mcu7t5v0__fillcap_8
XPHY_EDGE_ROW_78_Right_78 VDD VSS gf180mcu_fd_sc_mcu7t5v0__endcap
XFILLER_88_61 VDD VDD VSS VSS gf180mcu_fd_sc_mcu7t5v0__fill_1
XFILLER_111_236 VDD VDD VSS VSS gf180mcu_fd_sc_mcu7t5v0__fill_1
X_2250_ _2250_/A1 _2250_/A2 _3805_/D VDD VDD VSS VSS gf180mcu_fd_sc_mcu7t5v0__nor2_1
XFILLER_69_139 VDD VDD VSS VSS gf180mcu_fd_sc_mcu7t5v0__fill_1
Xclkbuf_1_0__f__1473__regs clkbuf_0__1473__regs/Z _3460__118/I VDD VDD VSS VSS gf180mcu_fd_sc_mcu7t5v0__clkbuf_16
XFILLER_77_183 VDD VDD VSS VSS gf180mcu_fd_sc_mcu7t5v0__fillcap_4
X_2181_ _2181_/A1 _2181_/A2 _3780_/D VDD VDD VSS VSS gf180mcu_fd_sc_mcu7t5v0__nor2_1
XTAP_TAPCELL_ROW_48_543 VDD VSS gf180mcu_fd_sc_mcu7t5v0__filltie
XTAP_TAPCELL_ROW_91_800 VDD VSS gf180mcu_fd_sc_mcu7t5v0__filltie
XFILLER_18_283 VDD VDD VSS VSS gf180mcu_fd_sc_mcu7t5v0__fill_2
XPHY_EDGE_ROW_87_Right_87 VDD VSS gf180mcu_fd_sc_mcu7t5v0__endcap
X_1965_ _3980_/Q _3168_/A1 VDD VDD VSS VSS gf180mcu_fd_sc_mcu7t5v0__clkinv_1
X_3704_ _3750_/I1 _3699_/Z _3705_/B VDD VDD VSS VSS gf180mcu_fd_sc_mcu7t5v0__nand2_1
X_1896_ _4090_/Q _3506_/A1 VDD VDD VSS VSS gf180mcu_fd_sc_mcu7t5v0__clkinv_1
X_3635_ _3635_/A1 _3635_/A2 _3636_/C VDD VDD VSS VSS gf180mcu_fd_sc_mcu7t5v0__nand2_1
XPHY_EDGE_ROW_96_Right_96 VDD VSS gf180mcu_fd_sc_mcu7t5v0__endcap
X_3566_ _3554_/Z _3566_/A2 _3566_/B _3567_/A3 VDD VDD VSS VSS gf180mcu_fd_sc_mcu7t5v0__aoi21_1
X_2517_ _2525_/A1 _2517_/A2 _2509_/Z _2516_/Z _2518_/A2 VDD VDD VSS VSS gf180mcu_fd_sc_mcu7t5v0__aoi22_1
XFILLER_0_308 VDD VDD VSS VSS gf180mcu_fd_sc_mcu7t5v0__fillcap_32
X_3497_ _4088_/Q _3492_/I _3497_/Z VDD VDD VSS VSS gf180mcu_fd_sc_mcu7t5v0__xor2_1
X_2448_ _3813_/Q _2451_/A2 _3256_/B _2449_/A2 VDD VDD VSS VSS gf180mcu_fd_sc_mcu7t5v0__oai21_1
XFILLER_102_214 VDD VDD VSS VSS gf180mcu_fd_sc_mcu7t5v0__fillcap_16
XFILLER_102_247 VDD VDD VSS VSS gf180mcu_fd_sc_mcu7t5v0__fillcap_4
X_2379_ _2379_/A1 _3883_/Q _2379_/Z VDD VDD VSS VSS gf180mcu_fd_sc_mcu7t5v0__or2_1
X_4118_ _4118_/D _4142_/CLK _4118_/Q VDD VDD VSS VSS gf180mcu_fd_sc_mcu7t5v0__dffq_1
X_4049_ _4049_/D _4052_/CLK _4049_/Q VDD VDD VSS VSS gf180mcu_fd_sc_mcu7t5v0__dffq_1
XFILLER_17_35 VDD VDD VSS VSS gf180mcu_fd_sc_mcu7t5v0__fill_2
XTAP_TAPCELL_ROW_54_579 VDD VSS gf180mcu_fd_sc_mcu7t5v0__filltie
XFILLER_8_419 VDD VDD VSS VSS gf180mcu_fd_sc_mcu7t5v0__fillcap_4
XTAP_TAPCELL_ROW_45_524 VDD VSS gf180mcu_fd_sc_mcu7t5v0__filltie
XFILLER_62_337 VDD VDD VSS VSS gf180mcu_fd_sc_mcu7t5v0__fill_1
Xclkbuf_1_0__f__1473_ clkbuf_0__1473_/Z clkbuf_leaf_4__1473_/I VDD VDD VSS VSS gf180mcu_fd_sc_mcu7t5v0__clkbuf_16
X_3420_ _4072_/Q _3418_/Z _3439_/B _3421_/B VDD VDD VSS VSS gf180mcu_fd_sc_mcu7t5v0__oai21_1
X_3351_ _4057_/Q _4056_/Q _3345_/Z _3351_/Z VDD VDD VSS VSS gf180mcu_fd_sc_mcu7t5v0__and3_1
XFILLER_99_93 VDD VDD VSS VSS gf180mcu_fd_sc_mcu7t5v0__fill_2
X_2302_ _2536_/A1 _2300_/S _2302_/B _3811_/D VDD VDD VSS VSS gf180mcu_fd_sc_mcu7t5v0__aoi21_1
XFILLER_97_212 VDD VDD VSS VSS gf180mcu_fd_sc_mcu7t5v0__fillcap_8
X_3282_ wire91/Z _3283_/A2 wire81/Z _3283_/B VDD VDD VSS VSS gf180mcu_fd_sc_mcu7t5v0__oai21_1
XFILLER_24_2 VDD VDD VSS VSS gf180mcu_fd_sc_mcu7t5v0__fillcap_4
XFILLER_38_312 VDD VDD VSS VSS gf180mcu_fd_sc_mcu7t5v0__fill_2
X_2233_ _3799_/Q _2111_/Z _3746_/B _2234_/A2 VDD VDD VSS VSS gf180mcu_fd_sc_mcu7t5v0__oai21_1
X_2164_ _4056_/Q _2242_/A2 _2166_/A1 VDD VDD VSS VSS gf180mcu_fd_sc_mcu7t5v0__nor2_1
XFILLER_38_378 VDD VDD VSS VSS gf180mcu_fd_sc_mcu7t5v0__fill_2
XFILLER_65_142 VDD VDD VSS VSS gf180mcu_fd_sc_mcu7t5v0__fill_1
X_2095_ _3844_/Q _3843_/Q _3841_/Q _2940_/A2 VDD VDD VSS VSS gf180mcu_fd_sc_mcu7t5v0__nor3_1
X_2997_ _2997_/A1 _2997_/A2 _2997_/A3 _2997_/A4 _2997_/Z VDD VDD VSS VSS gf180mcu_fd_sc_mcu7t5v0__and4_1
X_1948_ _3997_/Q _3204_/A1 VDD VDD VSS VSS gf180mcu_fd_sc_mcu7t5v0__clkinv_1
X_1879_ _3853_/Q _3756_/A1 VDD VDD VSS VSS gf180mcu_fd_sc_mcu7t5v0__clkinv_1
X_3618_ _3618_/A1 _3618_/A2 _3618_/A3 _3620_/C1 VDD VDD VSS VSS gf180mcu_fd_sc_mcu7t5v0__nand3_1
X_3549_ _3549_/A1 _3461_/Z _3549_/B _3723_/B _3549_/ZN VDD VDD VSS VSS gf180mcu_fd_sc_mcu7t5v0__aoi211_1
XFILLER_0_138 VDD VDD VSS VSS gf180mcu_fd_sc_mcu7t5v0__fillcap_32
XTAP_TAPCELL_ROW_59_605 VDD VSS gf180mcu_fd_sc_mcu7t5v0__filltie
XFILLER_29_378 VDD VDD VSS VSS gf180mcu_fd_sc_mcu7t5v0__fill_1
XTAP_TAPCELL_ROW_42_505 VDD VSS gf180mcu_fd_sc_mcu7t5v0__filltie
XFILLER_71_189 VDD VDD VSS VSS gf180mcu_fd_sc_mcu7t5v0__fillcap_8
XFILLER_60_87 VDD VDD VSS VSS gf180mcu_fd_sc_mcu7t5v0__fillcap_4
XFILLER_106_350 VDD VDD VSS VSS gf180mcu_fd_sc_mcu7t5v0__fill_2
XTAP_TAPCELL_ROW_7_293 VDD VSS gf180mcu_fd_sc_mcu7t5v0__filltie
XFILLER_47_142 VDD VDD VSS VSS gf180mcu_fd_sc_mcu7t5v0__fillcap_8
X_2920_ _2920_/A1 _2920_/A2 _2919_/B _2920_/Z VDD VDD VSS VSS gf180mcu_fd_sc_mcu7t5v0__and3_1
X_2851_ _2844_/B _2843_/I _2863_/B _2863_/C _2858_/A2 VDD VDD VSS VSS gf180mcu_fd_sc_mcu7t5v0__oai211_1
X_2782_ _3956_/Q _3898_/Q _2791_/C VDD VDD VSS VSS gf180mcu_fd_sc_mcu7t5v0__nor2_1
XFILLER_7_282 VDD VDD VSS VSS gf180mcu_fd_sc_mcu7t5v0__fillcap_64
Xhold216 _3866_/Q hold216/Z VDD VDD VSS VSS gf180mcu_fd_sc_mcu7t5v0__dlyc_1
Xhold205 _3780_/Q hold205/Z VDD VDD VSS VSS gf180mcu_fd_sc_mcu7t5v0__dlyc_1
Xhold227 _4001_/Q _1944_/I VDD VDD VSS VSS gf180mcu_fd_sc_mcu7t5v0__dlyc_1
X_3403_ _4065_/Q _3398_/Z _3403_/B _4065_/D VDD VDD VSS VSS gf180mcu_fd_sc_mcu7t5v0__aoi21_1
X_3334_ _3395_/A1 _3334_/A2 _3333_/Z _4051_/D VDD VDD VSS VSS gf180mcu_fd_sc_mcu7t5v0__nor3_1
Xtop_level_95 ext_clk_in_pu_control VDD VDD VSS VSS gf180mcu_fd_sc_mcu7t5v0__tiel
X_3265_ wire91/Z _3274_/A2 wire81/Z _3266_/B VDD VDD VSS VSS gf180mcu_fd_sc_mcu7t5v0__oai21_1
X_2216_ _3506_/A1 _2111_/Z _2216_/B _3792_/D VDD VDD VSS VSS gf180mcu_fd_sc_mcu7t5v0__aoi21_1
X_3196_ _3196_/A1 _3206_/A2 _3196_/B _3993_/D VDD VDD VSS VSS gf180mcu_fd_sc_mcu7t5v0__aoi21_1
X_2147_ _3769_/Q _2243_/A2 _3746_/B _2148_/A2 VDD VDD VSS VSS gf180mcu_fd_sc_mcu7t5v0__oai21_1
X_2078_ _3806_/Q _2078_/ZN VDD VDD VSS VSS gf180mcu_fd_sc_mcu7t5v0__clkinv_1
XFILLER_14_47 VDD VDD VSS VSS gf180mcu_fd_sc_mcu7t5v0__fill_2
XFILLER_30_46 VDD VDD VSS VSS gf180mcu_fd_sc_mcu7t5v0__fillcap_4
XFILLER_103_320 VDD VDD VSS VSS gf180mcu_fd_sc_mcu7t5v0__fill_1
XTAP_TAPCELL_ROW_4_274 VDD VSS gf180mcu_fd_sc_mcu7t5v0__filltie
XTAP_TAPCELL_ROW_87_777 VDD VSS gf180mcu_fd_sc_mcu7t5v0__filltie
XFILLER_17_326 VDD VDD VSS VSS gf180mcu_fd_sc_mcu7t5v0__fillcap_4
XFILLER_55_76 VDD VDD VSS VSS gf180mcu_fd_sc_mcu7t5v0__fill_2
XFILLER_55_87 VDD VDD VSS VSS gf180mcu_fd_sc_mcu7t5v0__fillcap_8
XPHY_EDGE_ROW_105_Right_105 VDD VSS gf180mcu_fd_sc_mcu7t5v0__endcap
XFILLER_71_64 VDD VDD VSS VSS gf180mcu_fd_sc_mcu7t5v0__fillcap_4
XFILLER_121_172 VDD VDD VSS VSS gf180mcu_fd_sc_mcu7t5v0__fillcap_32
X_3050_ _3731_/C _3050_/A2 _3927_/D VDD VDD VSS VSS gf180mcu_fd_sc_mcu7t5v0__nor2_1
XTAP_TAPCELL_ROW_78_722 VDD VSS gf180mcu_fd_sc_mcu7t5v0__filltie
X_2001_ _3944_/Q _3092_/A1 VDD VDD VSS VSS gf180mcu_fd_sc_mcu7t5v0__clkinv_1
XFILLER_35_134 VDD VDD VSS VSS gf180mcu_fd_sc_mcu7t5v0__fillcap_4
X_3952_ _3952_/D _4162_/CLK _3952_/Q VDD VDD VSS VSS gf180mcu_fd_sc_mcu7t5v0__dffq_1
XFILLER_16_381 VDD VDD VSS VSS gf180mcu_fd_sc_mcu7t5v0__fillcap_4
X_3883_ _3883_/D clkload6/I _3883_/Q VDD VDD VSS VSS gf180mcu_fd_sc_mcu7t5v0__dffq_1
X_2903_ _2908_/A1 _2899_/Z _2903_/B _2904_/A2 VDD VDD VSS VSS gf180mcu_fd_sc_mcu7t5v0__oai21_1
X_2834_ _3962_/Q _3904_/Q _3903_/Q _3961_/Q _2835_/I VDD VDD VSS VSS gf180mcu_fd_sc_mcu7t5v0__oai211_1
XFILLER_31_373 VDD VDD VSS VSS gf180mcu_fd_sc_mcu7t5v0__fill_2
X_2765_ _2765_/A1 _2766_/A2 _2771_/B VDD VDD VSS VSS gf180mcu_fd_sc_mcu7t5v0__nor2_1
X_2696_ _2697_/A2 _2696_/A2 _2696_/A3 _2698_/A2 VDD VDD VSS VSS gf180mcu_fd_sc_mcu7t5v0__nand3_1
XFILLER_116_49 VDD VDD VSS VSS gf180mcu_fd_sc_mcu7t5v0__fillcap_4
X_3317_ _4046_/Q _3315_/Z _3319_/A2 VDD VDD VSS VSS gf180mcu_fd_sc_mcu7t5v0__nor2_1
X_3248_ wire91/I _3257_/A2 _3256_/B _3249_/B VDD VDD VSS VSS gf180mcu_fd_sc_mcu7t5v0__oai21_1
XFILLER_58_259 VDD VDD VSS VSS gf180mcu_fd_sc_mcu7t5v0__fillcap_4
X_3179_ _2591_/C wire44/Z _3179_/B _3985_/D VDD VDD VSS VSS gf180mcu_fd_sc_mcu7t5v0__aoi21_1
XFILLER_26_123 VDD VDD VSS VSS gf180mcu_fd_sc_mcu7t5v0__fillcap_8
XTAP_TAPCELL_ROW_84_758 VDD VSS gf180mcu_fd_sc_mcu7t5v0__filltie
XFILLER_1_277 VDD VDD VSS VSS gf180mcu_fd_sc_mcu7t5v0__fill_2
XFILLER_49_248 VDD VDD VSS VSS gf180mcu_fd_sc_mcu7t5v0__fill_2
XTAP_TAPCELL_ROW_75_703 VDD VSS gf180mcu_fd_sc_mcu7t5v0__filltie
XFILLER_17_112 VDD VDD VSS VSS gf180mcu_fd_sc_mcu7t5v0__fill_1
XFILLER_72_240 VDD VDD VSS VSS gf180mcu_fd_sc_mcu7t5v0__fillcap_4
XFILLER_82_52 VDD VDD VSS VSS gf180mcu_fd_sc_mcu7t5v0__fill_1
XFILLER_82_85 VDD VDD VSS VSS gf180mcu_fd_sc_mcu7t5v0__fillcap_4
XTAP_TAPCELL_ROW_23_390 VDD VSS gf180mcu_fd_sc_mcu7t5v0__filltie
XFILLER_63_6 VDD VDD VSS VSS gf180mcu_fd_sc_mcu7t5v0__fill_1
X_2550_ _2552_/A1 _4157_/Q _3883_/D VDD VDD VSS VSS gf180mcu_fd_sc_mcu7t5v0__nor2_1
X_2481_ _2481_/A1 _2481_/A2 _2482_/I0 VDD VDD VSS VSS gf180mcu_fd_sc_mcu7t5v0__nand2_1
XFILLER_99_104 VDD VDD VSS VSS gf180mcu_fd_sc_mcu7t5v0__fillcap_4
XFILLER_99_137 VDD VDD VSS VSS gf180mcu_fd_sc_mcu7t5v0__fill_2
XFILLER_99_148 VDD VDD VSS VSS gf180mcu_fd_sc_mcu7t5v0__fillcap_8
XTAP_TAPCELL_ROW_98_839 VDD VSS gf180mcu_fd_sc_mcu7t5v0__filltie
X_4151_ _4151_/D _4164_/CLK _4196_/I VDD VDD VSS VSS gf180mcu_fd_sc_mcu7t5v0__dffq_1
XFILLER_95_310 VDD VDD VSS VSS gf180mcu_fd_sc_mcu7t5v0__fill_2
X_3102_ _3102_/A1 _3104_/A2 _3102_/B _3949_/D VDD VDD VSS VSS gf180mcu_fd_sc_mcu7t5v0__aoi21_1
X_4082_ _4082_/D _4104_/CLK _4082_/Q VDD VDD VSS VSS gf180mcu_fd_sc_mcu7t5v0__dffq_1
XFILLER_95_365 VDD VDD VSS VSS gf180mcu_fd_sc_mcu7t5v0__fill_2
XTAP_TAPCELL_ROW_118_962 VDD VSS gf180mcu_fd_sc_mcu7t5v0__filltie
X_3033_ hold134/Z _3676_/A2 _3046_/B1 _3033_/B2 _3034_/A2 VDD VDD VSS VSS gf180mcu_fd_sc_mcu7t5v0__aoi22_1
XFILLER_63_273 VDD VDD VSS VSS gf180mcu_fd_sc_mcu7t5v0__fill_1
XTAP_TAPCELL_ROW_81_739 VDD VSS gf180mcu_fd_sc_mcu7t5v0__filltie
XFILLER_23_126 VDD VDD VSS VSS gf180mcu_fd_sc_mcu7t5v0__fill_2
X_3935_ _3935_/D _4170_/CLK _3935_/Q VDD VDD VSS VSS gf180mcu_fd_sc_mcu7t5v0__dffq_1
X_3866_ _3866_/D _4021_/CLK _3866_/Q VDD VDD VSS VSS gf180mcu_fd_sc_mcu7t5v0__dffq_1
X_2817_ _2929_/A1 _2816_/Z _3902_/D VDD VDD VSS VSS gf180mcu_fd_sc_mcu7t5v0__nor2_1
X_3797_ _3797_/D clkload3/I _3797_/Q VDD VDD VSS VSS gf180mcu_fd_sc_mcu7t5v0__dffq_1
X_2748_ _2736_/B _2748_/A2 _2748_/A3 _2749_/B VDD VDD VSS VSS gf180mcu_fd_sc_mcu7t5v0__and3_1
X_2679_ _2686_/A3 _2695_/B _2679_/A3 _2680_/A3 VDD VDD VSS VSS gf180mcu_fd_sc_mcu7t5v0__nor3_1
XFILLER_86_310 VDD VDD VSS VSS gf180mcu_fd_sc_mcu7t5v0__fillcap_4
XFILLER_100_142 VDD VDD VSS VSS gf180mcu_fd_sc_mcu7t5v0__fill_2
XTAP_TAPCELL_ROW_29_427 VDD VSS gf180mcu_fd_sc_mcu7t5v0__filltie
XFILLER_46_218 VDD VDD VSS VSS gf180mcu_fd_sc_mcu7t5v0__fillcap_4
XFILLER_14_104 VDD VDD VSS VSS gf180mcu_fd_sc_mcu7t5v0__fill_1
XFILLER_54_284 VDD VDD VSS VSS gf180mcu_fd_sc_mcu7t5v0__fillcap_4
XTAP_TAPCELL_ROW_12_327 VDD VSS gf180mcu_fd_sc_mcu7t5v0__filltie
XFILLER_6_303 VDD VDD VSS VSS gf180mcu_fd_sc_mcu7t5v0__fillcap_8
XTAP_TAPCELL_ROW_20_371 VDD VSS gf180mcu_fd_sc_mcu7t5v0__filltie
XFILLER_10_387 VDD VDD VSS VSS gf180mcu_fd_sc_mcu7t5v0__fillcap_32
XFILLER_96_107 VDD VDD VSS VSS gf180mcu_fd_sc_mcu7t5v0__fillcap_32
XFILLER_92_313 VDD VDD VSS VSS gf180mcu_fd_sc_mcu7t5v0__fill_2
XTAP_TAPCELL_ROW_115_943 VDD VSS gf180mcu_fd_sc_mcu7t5v0__filltie
XFILLER_20_107 VDD VDD VSS VSS gf180mcu_fd_sc_mcu7t5v0__fillcap_16
X_3720_ _3720_/A1 _3720_/A2 _3720_/A3 _3721_/A2 VDD VDD VSS VSS gf180mcu_fd_sc_mcu7t5v0__nor3_1
X_1981_ _3964_/Q _3134_/A1 VDD VDD VSS VSS gf180mcu_fd_sc_mcu7t5v0__clkinv_1
XFILLER_9_152 VDD VDD VSS VSS gf180mcu_fd_sc_mcu7t5v0__fill_1
X_3651_ _3731_/C _3651_/A2 _4119_/D VDD VDD VSS VSS gf180mcu_fd_sc_mcu7t5v0__nor2_1
X_3582_ _4112_/Q _3582_/A2 _3583_/A2 VDD VDD VSS VSS gf180mcu_fd_sc_mcu7t5v0__nand2_1
XFILLER_9_196 VDD VDD VSS VSS gf180mcu_fd_sc_mcu7t5v0__fillcap_8
X_2602_ _2563_/B _2602_/A2 _2602_/A3 _2602_/A4 _2603_/B VDD VDD VSS VSS gf180mcu_fd_sc_mcu7t5v0__nand4_1
X_2533_ _2549_/A2 _2533_/A2 _2546_/B _2540_/A2 VDD VDD VSS VSS gf180mcu_fd_sc_mcu7t5v0__aoi21_1
XFILLER_54_2 VDD VDD VSS VSS gf180mcu_fd_sc_mcu7t5v0__fillcap_4
X_2464_ _3881_/Q _2464_/A2 _2495_/C _2555_/A2 _2463_/Z _2465_/A2 VDD VDD VSS VSS gf180mcu_fd_sc_mcu7t5v0__oai32_1
X_2395_ _2395_/I _3841_/D VDD VDD VSS VSS gf180mcu_fd_sc_mcu7t5v0__clkinv_1
X_4134_ _4134_/D _4164_/CLK _4134_/Q VDD VDD VSS VSS gf180mcu_fd_sc_mcu7t5v0__dffq_1
X_4065_ _4065_/D _4073_/CLK _4065_/Q VDD VDD VSS VSS gf180mcu_fd_sc_mcu7t5v0__dffq_1
XTAP_TAPCELL_ROW_26_408 VDD VSS gf180mcu_fd_sc_mcu7t5v0__filltie
XFILLER_36_240 VDD VDD VSS VSS gf180mcu_fd_sc_mcu7t5v0__fillcap_4
Xwire44 wire44/I wire44/Z VDD VDD VSS VSS gf180mcu_fd_sc_mcu7t5v0__buf_3
X_3016_ _3016_/A1 _3016_/A2 _3016_/A3 _3016_/Z VDD VDD VSS VSS gf180mcu_fd_sc_mcu7t5v0__and3_1
Xwire77 wire77/I wire77/Z VDD VDD VSS VSS gf180mcu_fd_sc_mcu7t5v0__clkbuf_2
XTAP_TAPCELL_ROW_121_979 VDD VSS gf180mcu_fd_sc_mcu7t5v0__filltie
X_3918_ _3918_/D _4169_/CLK _3918_/Q VDD VDD VSS VSS gf180mcu_fd_sc_mcu7t5v0__dffq_1
X_3849_ _3849_/D clkload3/I _3849_/Q VDD VDD VSS VSS gf180mcu_fd_sc_mcu7t5v0__dffq_1
XFILLER_3_317 VDD VDD VSS VSS gf180mcu_fd_sc_mcu7t5v0__fillcap_32
XFILLER_105_212 VDD VDD VSS VSS gf180mcu_fd_sc_mcu7t5v0__fillcap_4
XFILLER_105_245 VDD VDD VSS VSS gf180mcu_fd_sc_mcu7t5v0__fillcap_8
XFILLER_120_215 VDD VDD VSS VSS gf180mcu_fd_sc_mcu7t5v0__fillcap_16
XFILLER_103_72 VDD VDD VSS VSS gf180mcu_fd_sc_mcu7t5v0__fillcap_8
XTAP_TAPCELL_ROW_112_924 VDD VSS gf180mcu_fd_sc_mcu7t5v0__filltie
XFILLER_42_232 VDD VDD VSS VSS gf180mcu_fd_sc_mcu7t5v0__fillcap_8
XFILLER_10_195 VDD VDD VSS VSS gf180mcu_fd_sc_mcu7t5v0__fill_2
XFILLER_6_177 VDD VDD VSS VSS gf180mcu_fd_sc_mcu7t5v0__fill_1
XFILLER_12_91 VDD VDD VSS VSS gf180mcu_fd_sc_mcu7t5v0__fill_2
X_2180_ hold205/Z _2243_/A2 _3746_/B _2181_/A2 VDD VDD VSS VSS gf180mcu_fd_sc_mcu7t5v0__oai21_1
XFILLER_77_151 VDD VDD VSS VSS gf180mcu_fd_sc_mcu7t5v0__fillcap_32
XFILLER_65_346 VDD VDD VSS VSS gf180mcu_fd_sc_mcu7t5v0__fillcap_4
XFILLER_92_132 VDD VDD VSS VSS gf180mcu_fd_sc_mcu7t5v0__fillcap_4
XTAP_TAPCELL_ROW_91_801 VDD VSS gf180mcu_fd_sc_mcu7t5v0__filltie
XFILLER_92_143 VDD VDD VSS VSS gf180mcu_fd_sc_mcu7t5v0__fillcap_8
XFILLER_18_295 VDD VDD VSS VSS gf180mcu_fd_sc_mcu7t5v0__fillcap_8
XFILLER_33_232 VDD VDD VSS VSS gf180mcu_fd_sc_mcu7t5v0__fill_2
X_1964_ _3981_/Q _3170_/A1 VDD VDD VSS VSS gf180mcu_fd_sc_mcu7t5v0__clkinv_1
XPHY_EDGE_ROW_78_Left_200 VDD VSS gf180mcu_fd_sc_mcu7t5v0__endcap
X_3703_ wire81/Z _3703_/A2 _3703_/A3 _4132_/D VDD VDD VSS VSS gf180mcu_fd_sc_mcu7t5v0__nand3_1
XFILLER_119_348 VDD VDD VSS VSS gf180mcu_fd_sc_mcu7t5v0__fill_2
X_1895_ _4091_/Q _3510_/A1 VDD VDD VSS VSS gf180mcu_fd_sc_mcu7t5v0__clkinv_1
X_3634_ _3794_/Q wire71/Z _3664_/B1 _3802_/Q _3635_/A2 VDD VDD VSS VSS gf180mcu_fd_sc_mcu7t5v0__aoi22_1
X_3565_ _4108_/Q _4107_/Q _3566_/A2 VDD VDD VSS VSS gf180mcu_fd_sc_mcu7t5v0__nand2_1
X_2516_ _2525_/A1 _3871_/Q _2516_/Z VDD VDD VSS VSS gf180mcu_fd_sc_mcu7t5v0__xor2_1
X_3496_ _4088_/Q _3492_/I _3496_/Z VDD VDD VSS VSS gf180mcu_fd_sc_mcu7t5v0__and2_1
X_2447_ _3861_/Q _2430_/Z _2449_/A1 VDD VDD VSS VSS gf180mcu_fd_sc_mcu7t5v0__nor2_1
X_2378_ _2379_/A1 _3883_/Q _2495_/C VDD VDD VSS VSS gf180mcu_fd_sc_mcu7t5v0__nand2_1
X_4117_ _4117_/D _4149_/CLK _4117_/Q VDD VDD VSS VSS gf180mcu_fd_sc_mcu7t5v0__dffq_1
X_4048_ _4048_/D _4052_/CLK _4048_/Q VDD VDD VSS VSS gf180mcu_fd_sc_mcu7t5v0__dffq_1
XFILLER_17_69 VDD VDD VSS VSS gf180mcu_fd_sc_mcu7t5v0__fill_1
XFILLER_71_349 VDD VDD VSS VSS gf180mcu_fd_sc_mcu7t5v0__fill_1
XFILLER_33_35 VDD VDD VSS VSS gf180mcu_fd_sc_mcu7t5v0__fill_2
XFILLER_116_4 VDD VDD VSS VSS gf180mcu_fd_sc_mcu7t5v0__fill_1
XFILLER_79_416 VDD VDD VSS VSS gf180mcu_fd_sc_mcu7t5v0__fillcap_4
XFILLER_74_20 VDD VDD VSS VSS gf180mcu_fd_sc_mcu7t5v0__fill_2
XTAP_TAPCELL_ROW_45_525 VDD VSS gf180mcu_fd_sc_mcu7t5v0__filltie
XFILLER_15_298 VDD VDD VSS VSS gf180mcu_fd_sc_mcu7t5v0__fillcap_4
XFILLER_30_224 VDD VDD VSS VSS gf180mcu_fd_sc_mcu7t5v0__fill_1
XFILLER_30_279 VDD VDD VSS VSS gf180mcu_fd_sc_mcu7t5v0__fillcap_32
XFILLER_116_307 VDD VDD VSS VSS gf180mcu_fd_sc_mcu7t5v0__fill_2
XFILLER_109_381 VDD VDD VSS VSS gf180mcu_fd_sc_mcu7t5v0__fillcap_32
X_3350_ _4056_/Q _3345_/Z _4057_/Q _3352_/A2 VDD VDD VSS VSS gf180mcu_fd_sc_mcu7t5v0__aoi21_1
X_2301_ _3810_/Q _2300_/S _2302_/B VDD VDD VSS VSS gf180mcu_fd_sc_mcu7t5v0__nor2_1
X_3281_ _2683_/C _3283_/A2 _3281_/B _4033_/D VDD VDD VSS VSS gf180mcu_fd_sc_mcu7t5v0__aoi21_1
X_2232_ _4097_/Q _2248_/A2 _2234_/A1 VDD VDD VSS VSS gf180mcu_fd_sc_mcu7t5v0__nor2_1
XPHY_EDGE_ROW_119_Right_119 VDD VSS gf180mcu_fd_sc_mcu7t5v0__endcap
X_2163_ _2163_/A1 _2163_/A2 _3774_/D VDD VDD VSS VSS gf180mcu_fd_sc_mcu7t5v0__nor2_1
X_2094_ _3845_/Q _3746_/B _3671_/A1 VDD VDD VSS VSS gf180mcu_fd_sc_mcu7t5v0__nand2_1
XFILLER_65_176 VDD VDD VSS VSS gf180mcu_fd_sc_mcu7t5v0__fill_2
XFILLER_80_135 VDD VDD VSS VSS gf180mcu_fd_sc_mcu7t5v0__fillcap_4
XFILLER_119_101 VDD VDD VSS VSS gf180mcu_fd_sc_mcu7t5v0__fill_2
X_2996_ _3930_/Q _3060_/A1 _3057_/A1 _3929_/Q _2997_/A4 VDD VDD VSS VSS gf180mcu_fd_sc_mcu7t5v0__aoi22_1
X_1947_ _3998_/Q _3206_/A1 VDD VDD VSS VSS gf180mcu_fd_sc_mcu7t5v0__clkinv_1
X_1878_ _4141_/Q _3557_/B VDD VDD VSS VSS gf180mcu_fd_sc_mcu7t5v0__clkinv_1
X_3617_ _3792_/Q wire71/Z _3664_/B1 _3800_/Q _3618_/A3 VDD VDD VSS VSS gf180mcu_fd_sc_mcu7t5v0__aoi22_1
X_3548_ _3548_/A1 _3548_/A2 _3548_/B _4104_/D VDD VDD VSS VSS gf180mcu_fd_sc_mcu7t5v0__aoi21_1
XFILLER_88_213 VDD VDD VSS VSS gf180mcu_fd_sc_mcu7t5v0__fill_1
XFILLER_115_395 VDD VDD VSS VSS gf180mcu_fd_sc_mcu7t5v0__fillcap_16
X_3479_ _4084_/Q _3479_/A2 _3549_/B _3478_/Z _3480_/A2 VDD VDD VSS VSS gf180mcu_fd_sc_mcu7t5v0__aoi22_1
XFILLER_29_302 VDD VDD VSS VSS gf180mcu_fd_sc_mcu7t5v0__fillcap_4
XTAP_TAPCELL_ROW_59_606 VDD VSS gf180mcu_fd_sc_mcu7t5v0__filltie
XFILLER_29_346 VDD VDD VSS VSS gf180mcu_fd_sc_mcu7t5v0__fillcap_4
XFILLER_44_34 VDD VDD VSS VSS gf180mcu_fd_sc_mcu7t5v0__fill_1
XTAP_TAPCELL_ROW_42_506 VDD VSS gf180mcu_fd_sc_mcu7t5v0__filltie
XFILLER_44_89 VDD VDD VSS VSS gf180mcu_fd_sc_mcu7t5v0__fillcap_16
XTAP_TAPCELL_ROW_50_550 VDD VSS gf180mcu_fd_sc_mcu7t5v0__filltie
XFILLER_100_95 VDD VDD VSS VSS gf180mcu_fd_sc_mcu7t5v0__fill_2
XFILLER_121_2 VDD VDD VSS VSS gf180mcu_fd_sc_mcu7t5v0__fill_2
XFILLER_4_423 VDD VDD VSS VSS gf180mcu_fd_sc_mcu7t5v0__fill_2
XFILLER_106_384 VDD VDD VSS VSS gf180mcu_fd_sc_mcu7t5v0__fill_1
XFILLER_121_376 VDD VDD VSS VSS gf180mcu_fd_sc_mcu7t5v0__fillcap_32
XTAP_TAPCELL_ROW_7_294 VDD VSS gf180mcu_fd_sc_mcu7t5v0__filltie
Xclkbuf_leaf_3__1473_ clkbuf_leaf_4__1473_/I _3513_/A2 VDD VDD VSS VSS gf180mcu_fd_sc_mcu7t5v0__clkbuf_8
XFILLER_85_30 VDD VDD VSS VSS gf180mcu_fd_sc_mcu7t5v0__fill_1
XFILLER_94_238 VDD VDD VSS VSS gf180mcu_fd_sc_mcu7t5v0__fill_1
X_2850_ _2831_/Z _2863_/C _2850_/A3 _2865_/A3 VDD VDD VSS VSS gf180mcu_fd_sc_mcu7t5v0__nand3_1
X_2781_ _2760_/C _2781_/A2 _3897_/D VDD VDD VSS VSS gf180mcu_fd_sc_mcu7t5v0__nor2_1
XFILLER_116_104 VDD VDD VSS VSS gf180mcu_fd_sc_mcu7t5v0__fill_1
Xhold206 _3790_/Q hold206/Z VDD VDD VSS VSS gf180mcu_fd_sc_mcu7t5v0__dlyc_1
Xhold217 _4006_/Q _1939_/I VDD VDD VSS VSS gf180mcu_fd_sc_mcu7t5v0__dlyc_1
X_3402_ _4065_/Q _3398_/Z _3439_/B _3403_/B VDD VDD VSS VSS gf180mcu_fd_sc_mcu7t5v0__oai21_1
Xhold228 _3782_/Q hold228/Z VDD VDD VSS VSS gf180mcu_fd_sc_mcu7t5v0__dlyc_1
X_3333_ _4051_/Q _3330_/Z _3333_/Z VDD VDD VSS VSS gf180mcu_fd_sc_mcu7t5v0__and2_1
Xtop_level_96 i2c_scl_in_pd_control VDD VDD VSS VSS gf180mcu_fd_sc_mcu7t5v0__tiel
XPHY_EDGE_ROW_7_Right_7 VDD VSS gf180mcu_fd_sc_mcu7t5v0__endcap
X_3264_ _3264_/A1 _3274_/A2 _3264_/B _4025_/D VDD VDD VSS VSS gf180mcu_fd_sc_mcu7t5v0__aoi21_1
XFILLER_105_18 VDD VDD VSS VSS gf180mcu_fd_sc_mcu7t5v0__fillcap_4
X_2215_ _3792_/Q _2111_/Z _3746_/B _2216_/B VDD VDD VSS VSS gf180mcu_fd_sc_mcu7t5v0__oai21_1
X_3195_ _3849_/Q _3206_/A2 wire81/Z _3196_/B VDD VDD VSS VSS gf180mcu_fd_sc_mcu7t5v0__oai21_1
XFILLER_121_17 VDD VDD VSS VSS gf180mcu_fd_sc_mcu7t5v0__fillcap_16
X_2146_ hold200/Z _2155_/A2 _2148_/A1 VDD VDD VSS VSS gf180mcu_fd_sc_mcu7t5v0__nor2_1
XFILLER_38_187 VDD VDD VSS VSS gf180mcu_fd_sc_mcu7t5v0__fillcap_8
XFILLER_81_422 VDD VDD VSS VSS gf180mcu_fd_sc_mcu7t5v0__fillcap_4
XFILLER_19_390 VDD VDD VSS VSS gf180mcu_fd_sc_mcu7t5v0__fillcap_16
X_2077_ input3/Z _4156_/D VDD VDD VSS VSS gf180mcu_fd_sc_mcu7t5v0__clkinv_1
X_2979_ _2345_/C _2979_/A2 _3920_/D VDD VDD VSS VSS gf180mcu_fd_sc_mcu7t5v0__nor2_1
XPHY_EDGE_ROW_15_Left_137 VDD VSS gf180mcu_fd_sc_mcu7t5v0__endcap
XFILLER_30_69 VDD VDD VSS VSS gf180mcu_fd_sc_mcu7t5v0__fillcap_32
XFILLER_49_419 VDD VDD VSS VSS gf180mcu_fd_sc_mcu7t5v0__fill_1
XPHY_EDGE_ROW_24_Left_146 VDD VSS gf180mcu_fd_sc_mcu7t5v0__endcap
XTAP_TAPCELL_ROW_4_275 VDD VSS gf180mcu_fd_sc_mcu7t5v0__filltie
XFILLER_55_99 VDD VDD VSS VSS gf180mcu_fd_sc_mcu7t5v0__fill_2
XFILLER_111_72 VDD VDD VSS VSS gf180mcu_fd_sc_mcu7t5v0__fillcap_16
XPHY_EDGE_ROW_33_Left_155 VDD VSS gf180mcu_fd_sc_mcu7t5v0__endcap
XPHY_EDGE_ROW_42_Left_164 VDD VSS gf180mcu_fd_sc_mcu7t5v0__endcap
XTAP_TAPCELL_ROW_78_723 VDD VSS gf180mcu_fd_sc_mcu7t5v0__filltie
X_2000_ _3945_/Q _3094_/A1 VDD VDD VSS VSS gf180mcu_fd_sc_mcu7t5v0__clkinv_1
XFILLER_63_422 VDD VDD VSS VSS gf180mcu_fd_sc_mcu7t5v0__fillcap_4
XFILLER_75_282 VDD VDD VSS VSS gf180mcu_fd_sc_mcu7t5v0__fillcap_8
XFILLER_35_146 VDD VDD VSS VSS gf180mcu_fd_sc_mcu7t5v0__fillcap_8
X_3951_ _3951_/D _4162_/CLK _3951_/Q VDD VDD VSS VSS gf180mcu_fd_sc_mcu7t5v0__dffq_1
X_2902_ _3151_/A1 _3914_/Q _2902_/Z VDD VDD VSS VSS gf180mcu_fd_sc_mcu7t5v0__xor2_1
X_3882_ _3882_/D clkload6/I _3882_/Q VDD VDD VSS VSS gf180mcu_fd_sc_mcu7t5v0__dffq_1
X_2833_ _2823_/B _2833_/A2 _2865_/A2 VDD VDD VSS VSS gf180mcu_fd_sc_mcu7t5v0__nand2_1
XPHY_EDGE_ROW_51_Left_173 VDD VSS gf180mcu_fd_sc_mcu7t5v0__endcap
X_2764_ _2750_/Z _2757_/Z _2764_/B _2766_/A2 VDD VDD VSS VSS gf180mcu_fd_sc_mcu7t5v0__aoi21_1
X_2695_ _2695_/A1 _2695_/A2 _2695_/B _2698_/A1 VDD VDD VSS VSS gf180mcu_fd_sc_mcu7t5v0__aoi21_1
XFILLER_6_71 VDD VDD VSS VSS gf180mcu_fd_sc_mcu7t5v0__fillcap_4
XFILLER_104_107 VDD VDD VSS VSS gf180mcu_fd_sc_mcu7t5v0__fillcap_8
XPHY_EDGE_ROW_60_Left_182 VDD VSS gf180mcu_fd_sc_mcu7t5v0__endcap
X_3316_ _3395_/A1 _3316_/A2 _3315_/Z _4045_/D VDD VDD VSS VSS gf180mcu_fd_sc_mcu7t5v0__nor3_1
X_3247_ _3247_/A1 _3257_/A2 _3247_/B _4017_/D VDD VDD VSS VSS gf180mcu_fd_sc_mcu7t5v0__aoi21_1
X_3178_ _3849_/Q wire44/Z wire81/I _3179_/B VDD VDD VSS VSS gf180mcu_fd_sc_mcu7t5v0__oai21_1
XTAP_TAPCELL_ROW_1_256 VDD VSS gf180mcu_fd_sc_mcu7t5v0__filltie
XTAP_TAPCELL_ROW_84_759 VDD VSS gf180mcu_fd_sc_mcu7t5v0__filltie
X_2129_ _3763_/Q _2243_/A2 _3746_/B _2130_/A2 VDD VDD VSS VSS gf180mcu_fd_sc_mcu7t5v0__oai21_1
XFILLER_41_116 VDD VDD VSS VSS gf180mcu_fd_sc_mcu7t5v0__fillcap_4
XFILLER_41_138 VDD VDD VSS VSS gf180mcu_fd_sc_mcu7t5v0__fill_2
XFILLER_22_330 VDD VDD VSS VSS gf180mcu_fd_sc_mcu7t5v0__fill_1
Xclkbuf_0_signal_input clkbuf_0_signal_input/I clkbuf_0_signal_input/Z VDD VDD VSS
+ VSS gf180mcu_fd_sc_mcu7t5v0__clkbuf_16
XFILLER_1_212 VDD VDD VSS VSS gf180mcu_fd_sc_mcu7t5v0__fillcap_16
XFILLER_1_267 VDD VDD VSS VSS gf180mcu_fd_sc_mcu7t5v0__fillcap_4
XFILLER_89_352 VDD VDD VSS VSS gf180mcu_fd_sc_mcu7t5v0__fill_2
XTAP_TAPCELL_ROW_75_704 VDD VSS gf180mcu_fd_sc_mcu7t5v0__filltie
XFILLER_45_422 VDD VDD VSS VSS gf180mcu_fd_sc_mcu7t5v0__fillcap_4
XFILLER_60_425 VDD VDD VSS VSS gf180mcu_fd_sc_mcu7t5v0__fill_1
XFILLER_82_42 VDD VDD VSS VSS gf180mcu_fd_sc_mcu7t5v0__fill_2
XFILLER_13_352 VDD VDD VSS VSS gf180mcu_fd_sc_mcu7t5v0__fillcap_64
XFILLER_13_330 VDD VDD VSS VSS gf180mcu_fd_sc_mcu7t5v0__fillcap_4
XFILLER_15_80 VDD VDD VSS VSS gf180mcu_fd_sc_mcu7t5v0__fill_2
XTAP_TAPCELL_ROW_23_391 VDD VSS gf180mcu_fd_sc_mcu7t5v0__filltie
X_2480_ _4117_/Q _3920_/Q _2496_/B _2481_/A2 VDD VDD VSS VSS gf180mcu_fd_sc_mcu7t5v0__oai21_1
X_4150_ _4150_/D _4164_/CLK _4195_/I VDD VDD VSS VSS gf180mcu_fd_sc_mcu7t5v0__dffq_1
X_3101_ _3288_/A1 _3104_/A2 wire81/I _3102_/B VDD VDD VSS VSS gf180mcu_fd_sc_mcu7t5v0__oai21_1
X_4081_ _4081_/D _4104_/CLK _4081_/Q VDD VDD VSS VSS gf180mcu_fd_sc_mcu7t5v0__dffq_1
XTAP_TAPCELL_ROW_118_963 VDD VSS gf180mcu_fd_sc_mcu7t5v0__filltie
X_3032_ _3032_/A1 _3032_/A2 _3032_/A3 _3033_/B2 VDD VDD VSS VSS gf180mcu_fd_sc_mcu7t5v0__nand3_1
XFILLER_63_252 VDD VDD VSS VSS gf180mcu_fd_sc_mcu7t5v0__fillcap_4
X_3934_ _3934_/D _4169_/CLK _3934_/Q VDD VDD VSS VSS gf180mcu_fd_sc_mcu7t5v0__dffq_1
X_3865_ _3865_/D _4021_/CLK _3865_/Q VDD VDD VSS VSS gf180mcu_fd_sc_mcu7t5v0__dffq_1
X_2816_ _2814_/Z _2816_/A2 _2816_/Z VDD VDD VSS VSS gf180mcu_fd_sc_mcu7t5v0__xor2_1
X_3796_ _3796_/D clkload3/I _3796_/Q VDD VDD VSS VSS gf180mcu_fd_sc_mcu7t5v0__dffq_1
X_2747_ _3949_/Q _3891_/Q _2741_/Z _2748_/A3 VDD VDD VSS VSS gf180mcu_fd_sc_mcu7t5v0__nand3_1
X_2678_ _4028_/Q _2845_/A2 _2678_/B _2681_/A3 VDD VDD VSS VSS gf180mcu_fd_sc_mcu7t5v0__aoi21_1
XFILLER_105_405 VDD VDD VSS VSS gf180mcu_fd_sc_mcu7t5v0__fillcap_8
XFILLER_120_419 VDD VDD VSS VSS gf180mcu_fd_sc_mcu7t5v0__fillcap_4
XFILLER_27_422 VDD VDD VSS VSS gf180mcu_fd_sc_mcu7t5v0__fillcap_4
XTAP_TAPCELL_ROW_29_428 VDD VSS gf180mcu_fd_sc_mcu7t5v0__filltie
XFILLER_36_24 VDD VDD VSS VSS gf180mcu_fd_sc_mcu7t5v0__fill_2
XFILLER_39_282 VDD VDD VSS VSS gf180mcu_fd_sc_mcu7t5v0__fillcap_16
XFILLER_36_79 VDD VDD VSS VSS gf180mcu_fd_sc_mcu7t5v0__fillcap_8
XTAP_TAPCELL_ROW_37_472 VDD VSS gf180mcu_fd_sc_mcu7t5v0__filltie
XFILLER_22_193 VDD VDD VSS VSS gf180mcu_fd_sc_mcu7t5v0__fill_2
XFILLER_10_311 VDD VDD VSS VSS gf180mcu_fd_sc_mcu7t5v0__fillcap_4
XTAP_TAPCELL_ROW_20_372 VDD VSS gf180mcu_fd_sc_mcu7t5v0__filltie
XFILLER_111_419 VDD VDD VSS VSS gf180mcu_fd_sc_mcu7t5v0__fill_1
XFILLER_89_193 VDD VDD VSS VSS gf180mcu_fd_sc_mcu7t5v0__fillcap_16
XFILLER_92_336 VDD VDD VSS VSS gf180mcu_fd_sc_mcu7t5v0__fillcap_4
XTAP_TAPCELL_ROW_115_944 VDD VSS gf180mcu_fd_sc_mcu7t5v0__filltie
XFILLER_33_414 VDD VDD VSS VSS gf180mcu_fd_sc_mcu7t5v0__fillcap_4
XFILLER_45_274 VDD VDD VSS VSS gf180mcu_fd_sc_mcu7t5v0__fillcap_4
X_1980_ _3965_/Q _3136_/A1 VDD VDD VSS VSS gf180mcu_fd_sc_mcu7t5v0__clkinv_1
XFILLER_13_171 VDD VDD VSS VSS gf180mcu_fd_sc_mcu7t5v0__fillcap_32
XFILLER_60_299 VDD VDD VSS VSS gf180mcu_fd_sc_mcu7t5v0__fillcap_4
X_3650_ hold140/Z _3669_/A2 _3650_/B1 _3650_/B2 _3651_/A2 VDD VDD VSS VSS gf180mcu_fd_sc_mcu7t5v0__aoi22_1
X_3581_ _3581_/I _4112_/D VDD VDD VSS VSS gf180mcu_fd_sc_mcu7t5v0__clkinv_1
XFILLER_9_186 VDD VDD VSS VSS gf180mcu_fd_sc_mcu7t5v0__fill_1
X_2601_ _2601_/A1 _2568_/B _2601_/A3 _2601_/A4 _2602_/A4 VDD VDD VSS VSS gf180mcu_fd_sc_mcu7t5v0__nor4_1
X_2532_ _3875_/Q _2529_/Z _2533_/A2 VDD VDD VSS VSS gf180mcu_fd_sc_mcu7t5v0__nand2_1
X_2463_ _3872_/Q _3871_/Q _2517_/A2 _2463_/Z VDD VDD VSS VSS gf180mcu_fd_sc_mcu7t5v0__or3_1
X_2394_ _3875_/Q _2383_/I _2400_/B1 _3841_/Q _2395_/I VDD VDD VSS VSS gf180mcu_fd_sc_mcu7t5v0__aoi22_1
X_4133_ _4133_/D _4155_/CLK _4133_/Q VDD VDD VSS VSS gf180mcu_fd_sc_mcu7t5v0__dffq_1
X_4064_ _4064_/D _4073_/CLK _4064_/Q VDD VDD VSS VSS gf180mcu_fd_sc_mcu7t5v0__dffq_1
X_3015_ _3966_/Q _3036_/B1 _3042_/B1 _3958_/Q _3015_/C1 _3974_/Q _3016_/A3 VDD VDD
+ VSS VSS gf180mcu_fd_sc_mcu7t5v0__aoi222_1
XTAP_TAPCELL_ROW_26_409 VDD VSS gf180mcu_fd_sc_mcu7t5v0__filltie
XFILLER_24_425 VDD VDD VSS VSS gf180mcu_fd_sc_mcu7t5v0__fill_1
XFILLER_36_296 VDD VDD VSS VSS gf180mcu_fd_sc_mcu7t5v0__fillcap_16
XFILLER_51_200 VDD VDD VSS VSS gf180mcu_fd_sc_mcu7t5v0__fillcap_8
X_3917_ _3917_/D _4169_/CLK _3917_/Q VDD VDD VSS VSS gf180mcu_fd_sc_mcu7t5v0__dffq_1
XFILLER_22_37 VDD VDD VSS VSS gf180mcu_fd_sc_mcu7t5v0__fillcap_32
XFILLER_22_26 VDD VDD VSS VSS gf180mcu_fd_sc_mcu7t5v0__fill_2
X_3848_ _3848_/D _4142_/CLK _3848_/Q VDD VDD VSS VSS gf180mcu_fd_sc_mcu7t5v0__dffq_1
X_3779_ _3779_/D _4104_/CLK _3779_/Q VDD VDD VSS VSS gf180mcu_fd_sc_mcu7t5v0__dffq_1
XFILLER_105_224 VDD VDD VSS VSS gf180mcu_fd_sc_mcu7t5v0__fillcap_8
XFILLER_105_257 VDD VDD VSS VSS gf180mcu_fd_sc_mcu7t5v0__fillcap_8
XFILLER_113_290 VDD VDD VSS VSS gf180mcu_fd_sc_mcu7t5v0__fillcap_16
XFILLER_74_314 VDD VDD VSS VSS gf180mcu_fd_sc_mcu7t5v0__fill_1
XFILLER_86_163 VDD VDD VSS VSS gf180mcu_fd_sc_mcu7t5v0__fillcap_8
XFILLER_103_62 VDD VDD VSS VSS gf180mcu_fd_sc_mcu7t5v0__fill_2
XTAP_TAPCELL_ROW_112_925 VDD VSS gf180mcu_fd_sc_mcu7t5v0__filltie
XFILLER_42_244 VDD VDD VSS VSS gf180mcu_fd_sc_mcu7t5v0__fill_1
XFILLER_63_99 VDD VDD VSS VSS gf180mcu_fd_sc_mcu7t5v0__fill_1
XPHY_EDGE_ROW_7_Left_129 VDD VSS gf180mcu_fd_sc_mcu7t5v0__endcap
XFILLER_77_130 VDD VDD VSS VSS gf180mcu_fd_sc_mcu7t5v0__fillcap_8
XFILLER_18_241 VDD VDD VSS VSS gf180mcu_fd_sc_mcu7t5v0__fillcap_4
XFILLER_92_155 VDD VDD VSS VSS gf180mcu_fd_sc_mcu7t5v0__fill_2
XFILLER_18_263 VDD VDD VSS VSS gf180mcu_fd_sc_mcu7t5v0__fillcap_8
XFILLER_92_177 VDD VDD VSS VSS gf180mcu_fd_sc_mcu7t5v0__fillcap_16
XFILLER_21_417 VDD VDD VSS VSS gf180mcu_fd_sc_mcu7t5v0__fill_2
X_1963_ _3982_/Q _3172_/A1 VDD VDD VSS VSS gf180mcu_fd_sc_mcu7t5v0__clkinv_1
X_1894_ _4094_/Q _3523_/A1 VDD VDD VSS VSS gf180mcu_fd_sc_mcu7t5v0__clkinv_1
X_3702_ wire94/Z _3699_/Z _3703_/A3 VDD VDD VSS VSS gf180mcu_fd_sc_mcu7t5v0__nand2_1
X_3633_ _3786_/Q _3663_/A2 _3662_/A2 _3762_/Q _3635_/A1 VDD VDD VSS VSS gf180mcu_fd_sc_mcu7t5v0__aoi22_1
X_3564_ _4108_/Q _4107_/Q _3564_/Z VDD VDD VSS VSS gf180mcu_fd_sc_mcu7t5v0__and2_1
X_2515_ _3871_/Q _2525_/A4 _2509_/Z _2515_/B2 _2515_/C _3871_/D VDD VDD VSS VSS gf180mcu_fd_sc_mcu7t5v0__oai221_1
X_3495_ _3495_/A1 _3495_/A2 _4087_/D VDD VDD VSS VSS gf180mcu_fd_sc_mcu7t5v0__nor2_1
X_2446_ _2487_/B2 _2430_/Z _2446_/B _3256_/B _3860_/D VDD VDD VSS VSS gf180mcu_fd_sc_mcu7t5v0__oai211_1
Xclkbuf_leaf_16_ext_clk_in clkbuf_leaf_1_ext_clk_in/I clkload6/I VDD VDD VSS VSS gf180mcu_fd_sc_mcu7t5v0__clkbuf_8
X_2377_ _2377_/A1 _4157_/Q _3836_/D VDD VDD VSS VSS gf180mcu_fd_sc_mcu7t5v0__nor2_1
X_4116_ _4116_/D _4149_/CLK _4116_/Q VDD VDD VSS VSS gf180mcu_fd_sc_mcu7t5v0__dffq_1
X_4047_ _4047_/D _4052_/CLK _4047_/Q VDD VDD VSS VSS gf180mcu_fd_sc_mcu7t5v0__dffq_1
XFILLER_17_37 VDD VDD VSS VSS gf180mcu_fd_sc_mcu7t5v0__fill_1
XFILLER_24_211 VDD VDD VSS VSS gf180mcu_fd_sc_mcu7t5v0__fill_2
XFILLER_83_177 VDD VDD VSS VSS gf180mcu_fd_sc_mcu7t5v0__fill_2
XFILLER_24_233 VDD VDD VSS VSS gf180mcu_fd_sc_mcu7t5v0__fillcap_4
XFILLER_118_382 VDD VDD VSS VSS gf180mcu_fd_sc_mcu7t5v0__fill_2
XFILLER_3_137 VDD VDD VSS VSS gf180mcu_fd_sc_mcu7t5v0__fill_2
XFILLER_58_22 VDD VDD VSS VSS gf180mcu_fd_sc_mcu7t5v0__fillcap_8
XFILLER_101_282 VDD VDD VSS VSS gf180mcu_fd_sc_mcu7t5v0__fillcap_4
XFILLER_74_32 VDD VDD VSS VSS gf180mcu_fd_sc_mcu7t5v0__fill_2
XFILLER_74_166 VDD VDD VSS VSS gf180mcu_fd_sc_mcu7t5v0__fill_1
XFILLER_74_177 VDD VDD VSS VSS gf180mcu_fd_sc_mcu7t5v0__fill_1
XFILLER_15_277 VDD VDD VSS VSS gf180mcu_fd_sc_mcu7t5v0__fill_2
XFILLER_30_236 VDD VDD VSS VSS gf180mcu_fd_sc_mcu7t5v0__fillcap_8
XTAP_TAPCELL_ROW_53_570 VDD VSS gf180mcu_fd_sc_mcu7t5v0__filltie
XFILLER_90_64 VDD VDD VSS VSS gf180mcu_fd_sc_mcu7t5v0__fillcap_16
XFILLER_30_247 VDD VDD VSS VSS gf180mcu_fd_sc_mcu7t5v0__fillcap_16
XFILLER_23_80 VDD VDD VSS VSS gf180mcu_fd_sc_mcu7t5v0__fillcap_16
XFILLER_99_95 VDD VDD VSS VSS gf180mcu_fd_sc_mcu7t5v0__fill_1
X_2300_ _3809_/Q _3810_/Q _2300_/S _3810_/D VDD VDD VSS VSS gf180mcu_fd_sc_mcu7t5v0__mux2_2
X_3280_ _3751_/I1 _3283_/A2 wire81/Z _3281_/B VDD VDD VSS VSS gf180mcu_fd_sc_mcu7t5v0__oai21_1
X_2231_ _3450_/B _2111_/Z _2231_/B _3798_/D VDD VDD VSS VSS gf180mcu_fd_sc_mcu7t5v0__aoi21_1
XFILLER_38_314 VDD VDD VSS VSS gf180mcu_fd_sc_mcu7t5v0__fill_1
X_2162_ _3774_/Q _2243_/A2 _3746_/B _2163_/A2 VDD VDD VSS VSS gf180mcu_fd_sc_mcu7t5v0__oai21_1
XFILLER_38_369 VDD VDD VSS VSS gf180mcu_fd_sc_mcu7t5v0__fill_1
X_2093_ _3676_/A2 _3731_/C _3587_/B VDD VDD VSS VSS gf180mcu_fd_sc_mcu7t5v0__nor2_1
XFILLER_21_203 VDD VDD VSS VSS gf180mcu_fd_sc_mcu7t5v0__fill_1
X_2995_ _4012_/Q _3224_/A1 _3105_/A1 _3956_/Q _2997_/A3 VDD VDD VSS VSS gf180mcu_fd_sc_mcu7t5v0__aoi22_1
X_1946_ _1946_/I _3209_/A1 VDD VDD VSS VSS gf180mcu_fd_sc_mcu7t5v0__clkinv_1
XFILLER_119_179 VDD VDD VSS VSS gf180mcu_fd_sc_mcu7t5v0__fill_2
X_1877_ _4142_/Q _3548_/A1 VDD VDD VSS VSS gf180mcu_fd_sc_mcu7t5v0__clkinv_1
X_3616_ _3784_/Q _3663_/A2 _3662_/A2 _3760_/Q _3618_/A2 VDD VDD VSS VSS gf180mcu_fd_sc_mcu7t5v0__aoi22_1
X_3547_ _4104_/Q _3547_/A2 _3547_/B _3548_/B VDD VDD VSS VSS gf180mcu_fd_sc_mcu7t5v0__oai21_1
X_3478_ _4084_/Q _3474_/Z _3478_/Z VDD VDD VSS VSS gf180mcu_fd_sc_mcu7t5v0__xor2_1
X_2429_ _2525_/A1 _3871_/Q _2555_/A2 _2431_/A2 VDD VDD VSS VSS gf180mcu_fd_sc_mcu7t5v0__nor3_1
XTAP_TAPCELL_ROW_59_607 VDD VSS gf180mcu_fd_sc_mcu7t5v0__filltie
XFILLER_29_325 VDD VDD VSS VSS gf180mcu_fd_sc_mcu7t5v0__fillcap_4
XFILLER_44_306 VDD VDD VSS VSS gf180mcu_fd_sc_mcu7t5v0__fill_1
XFILLER_56_177 VDD VDD VSS VSS gf180mcu_fd_sc_mcu7t5v0__fillcap_4
XFILLER_71_136 VDD VDD VSS VSS gf180mcu_fd_sc_mcu7t5v0__fillcap_4
XFILLER_71_158 VDD VDD VSS VSS gf180mcu_fd_sc_mcu7t5v0__fill_2
XTAP_TAPCELL_ROW_42_507 VDD VSS gf180mcu_fd_sc_mcu7t5v0__filltie
XTAP_TAPCELL_ROW_50_551 VDD VSS gf180mcu_fd_sc_mcu7t5v0__filltie
XFILLER_60_45 VDD VDD VSS VSS gf180mcu_fd_sc_mcu7t5v0__fillcap_4
XPHY_EDGE_ROW_97_Left_219 VDD VSS gf180mcu_fd_sc_mcu7t5v0__endcap
XFILLER_109_61 VDD VDD VSS VSS gf180mcu_fd_sc_mcu7t5v0__fill_1
XTAP_TAPCELL_ROW_7_295 VDD VSS gf180mcu_fd_sc_mcu7t5v0__filltie
X_2780_ _2780_/A1 _2784_/B _2781_/A2 VDD VDD VSS VSS gf180mcu_fd_sc_mcu7t5v0__nand2_1
XFILLER_7_240 VDD VDD VSS VSS gf180mcu_fd_sc_mcu7t5v0__fill_1
XFILLER_7_262 VDD VDD VSS VSS gf180mcu_fd_sc_mcu7t5v0__fillcap_16
Xhold207 _3804_/Q hold207/Z VDD VDD VSS VSS gf180mcu_fd_sc_mcu7t5v0__dlyc_1
X_3401_ _3401_/I _3439_/B VDD VDD VSS VSS gf180mcu_fd_sc_mcu7t5v0__clkinv_1
Xhold229 _3766_/Q hold229/Z VDD VDD VSS VSS gf180mcu_fd_sc_mcu7t5v0__dlyc_1
Xhold218 _3759_/Q hold218/Z VDD VDD VSS VSS gf180mcu_fd_sc_mcu7t5v0__dlyc_1
X_3332_ _4051_/Q _3330_/Z _3334_/A2 VDD VDD VSS VSS gf180mcu_fd_sc_mcu7t5v0__nor2_1
XFILLER_112_333 VDD VDD VSS VSS gf180mcu_fd_sc_mcu7t5v0__fillcap_4
Xtop_level_97 i2c_sda_out_pd_control VDD VDD VSS VSS gf180mcu_fd_sc_mcu7t5v0__tiel
X_3263_ _3751_/I1 _3274_/A2 wire81/Z _3264_/B VDD VDD VSS VSS gf180mcu_fd_sc_mcu7t5v0__oai21_1
X_2214_ _2214_/A1 _2214_/A2 _3791_/D VDD VDD VSS VSS gf180mcu_fd_sc_mcu7t5v0__nor2_1
X_3194_ _3194_/A1 _3206_/A2 _3194_/B _3992_/D VDD VDD VSS VSS gf180mcu_fd_sc_mcu7t5v0__aoi21_1
XFILLER_78_280 VDD VDD VSS VSS gf180mcu_fd_sc_mcu7t5v0__fill_1
XFILLER_38_133 VDD VDD VSS VSS gf180mcu_fd_sc_mcu7t5v0__fillcap_4
X_2145_ _2145_/A1 _2145_/A2 _3768_/D VDD VDD VSS VSS gf180mcu_fd_sc_mcu7t5v0__nor2_1
XFILLER_26_317 VDD VDD VSS VSS gf180mcu_fd_sc_mcu7t5v0__fillcap_4
XFILLER_38_177 VDD VDD VSS VSS gf180mcu_fd_sc_mcu7t5v0__fill_2
XFILLER_93_261 VDD VDD VSS VSS gf180mcu_fd_sc_mcu7t5v0__fill_1
XFILLER_38_199 VDD VDD VSS VSS gf180mcu_fd_sc_mcu7t5v0__fill_2
X_2076_ _2076_/I _2470_/A1 VDD VDD VSS VSS gf180mcu_fd_sc_mcu7t5v0__clkinv_1
XFILLER_34_383 VDD VDD VSS VSS gf180mcu_fd_sc_mcu7t5v0__fill_2
XFILLER_14_49 VDD VDD VSS VSS gf180mcu_fd_sc_mcu7t5v0__fill_1
X_2978_ hold151/Z _3018_/A2 _3018_/B1 _2978_/B2 _2979_/A2 VDD VDD VSS VSS gf180mcu_fd_sc_mcu7t5v0__aoi22_1
X_1929_ _4016_/Q _3245_/A1 VDD VDD VSS VSS gf180mcu_fd_sc_mcu7t5v0__clkinv_1
XFILLER_30_15 VDD VDD VSS VSS gf180mcu_fd_sc_mcu7t5v0__fillcap_16
XFILLER_1_416 VDD VDD VSS VSS gf180mcu_fd_sc_mcu7t5v0__fillcap_4
Xclkbuf_leaf_6_ext_clk_in clkload0/I _4155_/CLK VDD VDD VSS VSS gf180mcu_fd_sc_mcu7t5v0__clkbuf_8
XFILLER_39_68 VDD VDD VSS VSS gf180mcu_fd_sc_mcu7t5v0__fill_2
XFILLER_29_122 VDD VDD VSS VSS gf180mcu_fd_sc_mcu7t5v0__fillcap_8
XFILLER_91_209 VDD VDD VSS VSS gf180mcu_fd_sc_mcu7t5v0__fill_1
XTAP_TAPCELL_ROW_4_276 VDD VSS gf180mcu_fd_sc_mcu7t5v0__filltie
XFILLER_71_22 VDD VDD VSS VSS gf180mcu_fd_sc_mcu7t5v0__fill_1
XFILLER_67_206 VDD VDD VSS VSS gf180mcu_fd_sc_mcu7t5v0__fillcap_4
X_3950_ _3950_/D clkload9/I _3950_/Q VDD VDD VSS VSS gf180mcu_fd_sc_mcu7t5v0__dffq_1
XFILLER_35_158 VDD VDD VSS VSS gf180mcu_fd_sc_mcu7t5v0__fill_2
X_2901_ _2760_/C _2901_/A2 _3913_/D VDD VDD VSS VSS gf180mcu_fd_sc_mcu7t5v0__nor2_1
X_3881_ _3881_/D _4142_/CLK _3881_/Q VDD VDD VSS VSS gf180mcu_fd_sc_mcu7t5v0__dffq_1
X_2832_ _2823_/B _2833_/A2 _2832_/Z VDD VDD VSS VSS gf180mcu_fd_sc_mcu7t5v0__and2_1
XFILLER_31_375 VDD VDD VSS VSS gf180mcu_fd_sc_mcu7t5v0__fill_1
X_2763_ _3109_/A1 _2763_/A2 _2763_/B _2764_/B VDD VDD VSS VSS gf180mcu_fd_sc_mcu7t5v0__oai21_1
XFILLER_77_2 VDD VDD VSS VSS gf180mcu_fd_sc_mcu7t5v0__fill_1
X_2694_ _2694_/A1 _2694_/A2 _2694_/B _2694_/C _2695_/A2 VDD VDD VSS VSS gf180mcu_fd_sc_mcu7t5v0__oai211_1
X_3315_ _4045_/Q _3310_/Z _3315_/Z VDD VDD VSS VSS gf180mcu_fd_sc_mcu7t5v0__and2_1
XFILLER_112_174 VDD VDD VSS VSS gf180mcu_fd_sc_mcu7t5v0__fill_1
X_3246_ _3849_/Q _3257_/A2 _3256_/B _3247_/B VDD VDD VSS VSS gf180mcu_fd_sc_mcu7t5v0__oai21_1
XFILLER_100_314 VDD VDD VSS VSS gf180mcu_fd_sc_mcu7t5v0__fill_1
X_3177_ _3177_/A1 wire44/Z _3177_/B _3984_/D VDD VDD VSS VSS gf180mcu_fd_sc_mcu7t5v0__aoi21_1
XTAP_TAPCELL_ROW_1_257 VDD VSS gf180mcu_fd_sc_mcu7t5v0__filltie
X_2128_ hold161/Z _2155_/A2 _2130_/A1 VDD VDD VSS VSS gf180mcu_fd_sc_mcu7t5v0__nor2_1
X_2059_ _3899_/Q _2598_/B VDD VDD VSS VSS gf180mcu_fd_sc_mcu7t5v0__clkinv_1
XFILLER_81_253 VDD VDD VSS VSS gf180mcu_fd_sc_mcu7t5v0__fillcap_16
XFILLER_25_37 VDD VDD VSS VSS gf180mcu_fd_sc_mcu7t5v0__fillcap_4
XFILLER_41_106 VDD VDD VSS VSS gf180mcu_fd_sc_mcu7t5v0__fill_1
XFILLER_108_425 VDD VDD VSS VSS gf180mcu_fd_sc_mcu7t5v0__fill_1
XFILLER_89_364 VDD VDD VSS VSS gf180mcu_fd_sc_mcu7t5v0__fillcap_8
XFILLER_1_279 VDD VDD VSS VSS gf180mcu_fd_sc_mcu7t5v0__fill_1
XFILLER_106_73 VDD VDD VSS VSS gf180mcu_fd_sc_mcu7t5v0__fill_2
XTAP_TAPCELL_ROW_75_705 VDD VSS gf180mcu_fd_sc_mcu7t5v0__filltie
XFILLER_66_99 VDD VDD VSS VSS gf180mcu_fd_sc_mcu7t5v0__fillcap_4
XFILLER_25_180 VDD VDD VSS VSS gf180mcu_fd_sc_mcu7t5v0__fill_1
XTAP_TAPCELL_ROW_23_392 VDD VSS gf180mcu_fd_sc_mcu7t5v0__filltie
XFILLER_9_335 VDD VDD VSS VSS gf180mcu_fd_sc_mcu7t5v0__fill_1
XFILLER_40_172 VDD VDD VSS VSS gf180mcu_fd_sc_mcu7t5v0__fill_2
XFILLER_31_80 VDD VDD VSS VSS gf180mcu_fd_sc_mcu7t5v0__fillcap_4
XFILLER_99_139 VDD VDD VSS VSS gf180mcu_fd_sc_mcu7t5v0__fill_1
X_3100_ _3100_/A1 _3104_/A2 _3100_/B _3948_/D VDD VDD VSS VSS gf180mcu_fd_sc_mcu7t5v0__aoi21_1
XFILLER_95_312 VDD VDD VSS VSS gf180mcu_fd_sc_mcu7t5v0__fill_1
X_4080_ _4080_/D _4104_/CLK _4080_/Q VDD VDD VSS VSS gf180mcu_fd_sc_mcu7t5v0__dffq_1
X_3031_ _4015_/Q _3036_/A2 _3031_/B _3031_/C _3032_/A3 VDD VDD VSS VSS gf180mcu_fd_sc_mcu7t5v0__aoi211_1
XFILLER_36_423 VDD VDD VSS VSS gf180mcu_fd_sc_mcu7t5v0__fill_2
XFILLER_23_128 VDD VDD VSS VSS gf180mcu_fd_sc_mcu7t5v0__fill_1
XFILLER_63_286 VDD VDD VSS VSS gf180mcu_fd_sc_mcu7t5v0__fillcap_32
XFILLER_23_139 VDD VDD VSS VSS gf180mcu_fd_sc_mcu7t5v0__fill_1
X_3933_ _3933_/D _4170_/CLK _3933_/Q VDD VDD VSS VSS gf180mcu_fd_sc_mcu7t5v0__dffq_1
XFILLER_31_150 VDD VDD VSS VSS gf180mcu_fd_sc_mcu7t5v0__fill_2
X_3864_ _3864_/D _4021_/CLK _3864_/Q VDD VDD VSS VSS gf180mcu_fd_sc_mcu7t5v0__dffq_1
X_2815_ wire31/Z _2819_/A1 _2815_/B _2816_/A2 VDD VDD VSS VSS gf180mcu_fd_sc_mcu7t5v0__oai21_1
X_3795_ _3795_/D _4104_/CLK _3795_/Q VDD VDD VSS VSS gf180mcu_fd_sc_mcu7t5v0__dffq_1
X_2746_ _3102_/A1 _2746_/A2 _2748_/A2 _2750_/A2 VDD VDD VSS VSS gf180mcu_fd_sc_mcu7t5v0__nand3_1
X_2677_ _3285_/A1 _3913_/Q _2677_/B _2677_/C _2681_/A2 VDD VDD VSS VSS gf180mcu_fd_sc_mcu7t5v0__aoi211_1
XFILLER_105_417 VDD VDD VSS VSS gf180mcu_fd_sc_mcu7t5v0__fill_2
XFILLER_86_301 VDD VDD VSS VSS gf180mcu_fd_sc_mcu7t5v0__fill_1
XFILLER_98_172 VDD VDD VSS VSS gf180mcu_fd_sc_mcu7t5v0__fill_2
X_3229_ _3849_/Q _3240_/A2 wire81/I _3230_/B VDD VDD VSS VSS gf180mcu_fd_sc_mcu7t5v0__oai21_1
XFILLER_100_177 VDD VDD VSS VSS gf180mcu_fd_sc_mcu7t5v0__fillcap_8
XTAP_TAPCELL_ROW_29_429 VDD VSS gf180mcu_fd_sc_mcu7t5v0__filltie
XFILLER_54_242 VDD VDD VSS VSS gf180mcu_fd_sc_mcu7t5v0__fill_2
XTAP_TAPCELL_ROW_37_473 VDD VSS gf180mcu_fd_sc_mcu7t5v0__filltie
XTAP_TAPCELL_ROW_80_730 VDD VSS gf180mcu_fd_sc_mcu7t5v0__filltie
XFILLER_22_172 VDD VDD VSS VSS gf180mcu_fd_sc_mcu7t5v0__fill_2
XTAP_TAPCELL_ROW_20_373 VDD VSS gf180mcu_fd_sc_mcu7t5v0__filltie
XFILLER_108_244 VDD VDD VSS VSS gf180mcu_fd_sc_mcu7t5v0__fill_1
XFILLER_7_2 VDD VDD VSS VSS gf180mcu_fd_sc_mcu7t5v0__fillcap_16
XFILLER_77_21 VDD VDD VSS VSS gf180mcu_fd_sc_mcu7t5v0__fill_1
XFILLER_89_150 VDD VDD VSS VSS gf180mcu_fd_sc_mcu7t5v0__fillcap_4
XFILLER_77_65 VDD VDD VSS VSS gf180mcu_fd_sc_mcu7t5v0__fillcap_4
XFILLER_18_423 VDD VDD VSS VSS gf180mcu_fd_sc_mcu7t5v0__fill_2
XFILLER_45_220 VDD VDD VSS VSS gf180mcu_fd_sc_mcu7t5v0__fillcap_4
XFILLER_92_326 VDD VDD VSS VSS gf180mcu_fd_sc_mcu7t5v0__fillcap_4
XTAP_TAPCELL_ROW_115_945 VDD VSS gf180mcu_fd_sc_mcu7t5v0__filltie
XFILLER_93_53 VDD VDD VSS VSS gf180mcu_fd_sc_mcu7t5v0__fillcap_4
X_3580_ _4112_/Q _3578_/B _3580_/B _3581_/I VDD VDD VSS VSS gf180mcu_fd_sc_mcu7t5v0__oai21_1
X_2600_ _3206_/A1 _3908_/Q _3901_/Q _3192_/A1 _2601_/A4 VDD VDD VSS VSS gf180mcu_fd_sc_mcu7t5v0__oai22_1
X_2531_ _2380_/Z _2531_/A2 _2529_/Z _2531_/B _3874_/D VDD VDD VSS VSS gf180mcu_fd_sc_mcu7t5v0__oai31_1
XFILLER_114_247 VDD VDD VSS VSS gf180mcu_fd_sc_mcu7t5v0__fillcap_4
X_2462_ _2455_/Z _2499_/A2 _2462_/B _2465_/A1 VDD VDD VSS VSS gf180mcu_fd_sc_mcu7t5v0__aoi21_1
XFILLER_87_109 VDD VDD VSS VSS gf180mcu_fd_sc_mcu7t5v0__fillcap_4
XFILLER_3_40 VDD VDD VSS VSS gf180mcu_fd_sc_mcu7t5v0__fill_1
X_2393_ _2393_/I _3840_/D VDD VDD VSS VSS gf180mcu_fd_sc_mcu7t5v0__clkinv_1
XFILLER_95_131 VDD VDD VSS VSS gf180mcu_fd_sc_mcu7t5v0__fill_1
X_4132_ _4132_/D _4155_/CLK _4132_/Q VDD VDD VSS VSS gf180mcu_fd_sc_mcu7t5v0__dffq_1
XFILLER_95_142 VDD VDD VSS VSS gf180mcu_fd_sc_mcu7t5v0__fill_2
X_4063_ _4063_/D _4073_/CLK _4063_/Q VDD VDD VSS VSS gf180mcu_fd_sc_mcu7t5v0__dffq_1
X_3014_ _4006_/Q _3014_/A2 _3156_/A1 _3982_/Q _3016_/A2 VDD VDD VSS VSS gf180mcu_fd_sc_mcu7t5v0__aoi22_1
XFILLER_51_223 VDD VDD VSS VSS gf180mcu_fd_sc_mcu7t5v0__fillcap_8
Xwire79 wire79/I wire79/Z VDD VDD VSS VSS gf180mcu_fd_sc_mcu7t5v0__clkbuf_1
XTAP_TAPCELL_ROW_34_454 VDD VSS gf180mcu_fd_sc_mcu7t5v0__filltie
X_3916_ _3916_/D _4166_/CLK _3916_/Q VDD VDD VSS VSS gf180mcu_fd_sc_mcu7t5v0__dffq_1
X_3847_ _3847_/D clkload7/I wire94/I VDD VDD VSS VSS gf180mcu_fd_sc_mcu7t5v0__dffq_1
X_3778_ _3778_/D _4104_/CLK _3778_/Q VDD VDD VSS VSS gf180mcu_fd_sc_mcu7t5v0__dffq_1
X_2729_ _2760_/C _2728_/Z _3890_/D VDD VDD VSS VSS gf180mcu_fd_sc_mcu7t5v0__nor2_1
XFILLER_105_203 VDD VDD VSS VSS gf180mcu_fd_sc_mcu7t5v0__fillcap_4
XFILLER_105_269 VDD VDD VSS VSS gf180mcu_fd_sc_mcu7t5v0__fill_1
XFILLER_120_239 VDD VDD VSS VSS gf180mcu_fd_sc_mcu7t5v0__fillcap_4
XFILLER_59_334 VDD VDD VSS VSS gf180mcu_fd_sc_mcu7t5v0__fill_2
XFILLER_86_131 VDD VDD VSS VSS gf180mcu_fd_sc_mcu7t5v0__fillcap_32
XFILLER_59_356 VDD VDD VSS VSS gf180mcu_fd_sc_mcu7t5v0__fill_1
XPHY_EDGE_ROW_29_Right_29 VDD VSS gf180mcu_fd_sc_mcu7t5v0__endcap
XFILLER_47_68 VDD VDD VSS VSS gf180mcu_fd_sc_mcu7t5v0__fill_2
XFILLER_27_220 VDD VDD VSS VSS gf180mcu_fd_sc_mcu7t5v0__fillcap_4
XTAP_TAPCELL_ROW_112_926 VDD VSS gf180mcu_fd_sc_mcu7t5v0__filltie
XTAP_TAPCELL_ROW_120_970 VDD VSS gf180mcu_fd_sc_mcu7t5v0__filltie
XPHY_EDGE_ROW_38_Right_38 VDD VSS gf180mcu_fd_sc_mcu7t5v0__endcap
XFILLER_10_164 VDD VDD VSS VSS gf180mcu_fd_sc_mcu7t5v0__fill_1
XFILLER_12_93 VDD VDD VSS VSS gf180mcu_fd_sc_mcu7t5v0__fill_1
XFILLER_111_206 VDD VDD VSS VSS gf180mcu_fd_sc_mcu7t5v0__fillcap_4
XFILLER_97_418 VDD VDD VSS VSS gf180mcu_fd_sc_mcu7t5v0__fill_2
XPHY_EDGE_ROW_47_Right_47 VDD VSS gf180mcu_fd_sc_mcu7t5v0__endcap
XFILLER_77_142 VDD VDD VSS VSS gf180mcu_fd_sc_mcu7t5v0__fillcap_4
XFILLER_18_275 VDD VDD VSS VSS gf180mcu_fd_sc_mcu7t5v0__fill_1
XFILLER_33_212 VDD VDD VSS VSS gf180mcu_fd_sc_mcu7t5v0__fill_2
XTAP_TAPCELL_ROW_56_590 VDD VSS gf180mcu_fd_sc_mcu7t5v0__filltie
XFILLER_33_278 VDD VDD VSS VSS gf180mcu_fd_sc_mcu7t5v0__fill_2
X_1962_ _3983_/Q _3175_/A1 VDD VDD VSS VSS gf180mcu_fd_sc_mcu7t5v0__clkinv_1
XPHY_EDGE_ROW_56_Right_56 VDD VSS gf180mcu_fd_sc_mcu7t5v0__endcap
XPHY_EDGE_ROW_117_Left_239 VDD VSS gf180mcu_fd_sc_mcu7t5v0__endcap
X_1893_ _4096_/Q _3450_/B VDD VDD VSS VSS gf180mcu_fd_sc_mcu7t5v0__clkinv_1
X_3701_ _4132_/Q _3717_/A2 _3703_/A2 VDD VDD VSS VSS gf180mcu_fd_sc_mcu7t5v0__nand2_1
X_3632_ _3731_/C _3632_/A2 _4117_/D VDD VDD VSS VSS gf180mcu_fd_sc_mcu7t5v0__nor2_1
X_3563_ _4108_/Q _3582_/A2 _3567_/A2 VDD VDD VSS VSS gf180mcu_fd_sc_mcu7t5v0__nor2_1
X_2514_ _3807_/Q _2548_/A2 _2515_/C VDD VDD VSS VSS gf180mcu_fd_sc_mcu7t5v0__nand2_1
X_3494_ _4087_/Q _3486_/Z _3538_/B _3495_/A2 VDD VDD VSS VSS gf180mcu_fd_sc_mcu7t5v0__oai21_1
X_2445_ _3812_/Q _2430_/Z _2446_/B VDD VDD VSS VSS gf180mcu_fd_sc_mcu7t5v0__nand2_1
XPHY_EDGE_ROW_65_Right_65 VDD VSS gf180mcu_fd_sc_mcu7t5v0__endcap
X_2376_ _2376_/A1 _4157_/Q _3835_/D VDD VDD VSS VSS gf180mcu_fd_sc_mcu7t5v0__nor2_1
X_4115_ _4115_/D _4149_/CLK _4115_/Q VDD VDD VSS VSS gf180mcu_fd_sc_mcu7t5v0__dffq_1
XFILLER_68_197 VDD VDD VSS VSS gf180mcu_fd_sc_mcu7t5v0__fill_2
X_4046_ _4046_/D _4052_/CLK _4046_/Q VDD VDD VSS VSS gf180mcu_fd_sc_mcu7t5v0__dffq_1
XFILLER_17_49 VDD VDD VSS VSS gf180mcu_fd_sc_mcu7t5v0__fillcap_16
XFILLER_83_167 VDD VDD VSS VSS gf180mcu_fd_sc_mcu7t5v0__fill_1
XPHY_EDGE_ROW_74_Right_74 VDD VSS gf180mcu_fd_sc_mcu7t5v0__endcap
XPHY_EDGE_ROW_83_Right_83 VDD VSS gf180mcu_fd_sc_mcu7t5v0__endcap
XFILLER_59_142 VDD VDD VSS VSS gf180mcu_fd_sc_mcu7t5v0__fill_2
XFILLER_74_22 VDD VDD VSS VSS gf180mcu_fd_sc_mcu7t5v0__fill_1
XFILLER_15_212 VDD VDD VSS VSS gf180mcu_fd_sc_mcu7t5v0__fill_2
XPHY_EDGE_ROW_92_Right_92 VDD VSS gf180mcu_fd_sc_mcu7t5v0__endcap
XTAP_TAPCELL_ROW_53_571 VDD VSS gf180mcu_fd_sc_mcu7t5v0__filltie
XFILLER_70_395 VDD VDD VSS VSS gf180mcu_fd_sc_mcu7t5v0__fill_2
XFILLER_90_54 VDD VDD VSS VSS gf180mcu_fd_sc_mcu7t5v0__fill_1
XFILLER_7_422 VDD VDD VSS VSS gf180mcu_fd_sc_mcu7t5v0__fillcap_4
XFILLER_99_85 VDD VDD VSS VSS gf180mcu_fd_sc_mcu7t5v0__fillcap_8
XFILLER_31_6 VDD VDD VSS VSS gf180mcu_fd_sc_mcu7t5v0__fill_2
X_2230_ _3798_/Q _2111_/Z _3746_/B _2231_/B VDD VDD VSS VSS gf180mcu_fd_sc_mcu7t5v0__oai21_1
X_2161_ hold179/Z _2242_/A2 _2163_/A1 VDD VDD VSS VSS gf180mcu_fd_sc_mcu7t5v0__nor2_1
X_2092_ _2092_/I _2112_/A1 VDD VDD VSS VSS gf180mcu_fd_sc_mcu7t5v0__clkinv_1
XFILLER_80_115 VDD VDD VSS VSS gf180mcu_fd_sc_mcu7t5v0__fillcap_4
X_2994_ _4036_/Q _3027_/C1 _3156_/A1 _3980_/Q _3044_/A2 _4028_/Q _2997_/A2 VDD VDD
+ VSS VSS gf180mcu_fd_sc_mcu7t5v0__aoi222_1
XPHY_EDGE_ROW_100_Right_100 VDD VSS gf180mcu_fd_sc_mcu7t5v0__endcap
XFILLER_9_72 VDD VDD VSS VSS gf180mcu_fd_sc_mcu7t5v0__fillcap_4
X_1945_ _4000_/Q _3211_/A1 VDD VDD VSS VSS gf180mcu_fd_sc_mcu7t5v0__clkinv_1
X_1876_ _4146_/Q _3744_/A1 VDD VDD VSS VSS gf180mcu_fd_sc_mcu7t5v0__clkinv_1
X_3615_ _3776_/Q _3662_/B1 _3663_/B1 _3768_/Q _3618_/A1 VDD VDD VSS VSS gf180mcu_fd_sc_mcu7t5v0__aoi22_1
X_3546_ _3723_/B _3549_/B _3546_/ZN VDD VDD VSS VSS gf180mcu_fd_sc_mcu7t5v0__nor2_1
XFILLER_115_364 VDD VDD VSS VSS gf180mcu_fd_sc_mcu7t5v0__fill_2
X_3477_ _3552_/C _3477_/A2 _4083_/D VDD VDD VSS VSS gf180mcu_fd_sc_mcu7t5v0__nor2_1
X_2428_ _3818_/Q _2505_/A2 _2428_/B _2453_/B _2555_/A2 VDD VDD VSS VSS gf180mcu_fd_sc_mcu7t5v0__oai211_1
XTAP_TAPCELL_ROW_59_608 VDD VSS gf180mcu_fd_sc_mcu7t5v0__filltie
XFILLER_28_37 VDD VDD VSS VSS gf180mcu_fd_sc_mcu7t5v0__fillcap_16
X_2359_ _2362_/C _2358_/Z _3823_/D VDD VDD VSS VSS gf180mcu_fd_sc_mcu7t5v0__nor2_1
XFILLER_56_156 VDD VDD VSS VSS gf180mcu_fd_sc_mcu7t5v0__fillcap_4
XTAP_TAPCELL_ROW_67_652 VDD VSS gf180mcu_fd_sc_mcu7t5v0__filltie
X_4029_ _4029_/D _4166_/CLK _4029_/Q VDD VDD VSS VSS gf180mcu_fd_sc_mcu7t5v0__dffq_1
XFILLER_44_69 VDD VDD VSS VSS gf180mcu_fd_sc_mcu7t5v0__fillcap_8
XFILLER_100_31 VDD VDD VSS VSS gf180mcu_fd_sc_mcu7t5v0__fillcap_4
XTAP_TAPCELL_ROW_50_552 VDD VSS gf180mcu_fd_sc_mcu7t5v0__filltie
XFILLER_121_4 VDD VDD VSS VSS gf180mcu_fd_sc_mcu7t5v0__fill_1
XFILLER_60_79 VDD VDD VSS VSS gf180mcu_fd_sc_mcu7t5v0__fillcap_8
XFILLER_4_425 VDD VDD VSS VSS gf180mcu_fd_sc_mcu7t5v0__fill_1
XFILLER_121_301 VDD VDD VSS VSS gf180mcu_fd_sc_mcu7t5v0__fillcap_4
XFILLER_109_95 VDD VDD VSS VSS gf180mcu_fd_sc_mcu7t5v0__fillcap_8
XFILLER_79_204 VDD VDD VSS VSS gf180mcu_fd_sc_mcu7t5v0__fillcap_4
XFILLER_79_259 VDD VDD VSS VSS gf180mcu_fd_sc_mcu7t5v0__fillcap_4
XTAP_TAPCELL_ROW_7_296 VDD VSS gf180mcu_fd_sc_mcu7t5v0__filltie
XFILLER_87_270 VDD VDD VSS VSS gf180mcu_fd_sc_mcu7t5v0__fillcap_8
XFILLER_62_104 VDD VDD VSS VSS gf180mcu_fd_sc_mcu7t5v0__fill_1
XFILLER_28_370 VDD VDD VSS VSS gf180mcu_fd_sc_mcu7t5v0__fillcap_8
XFILLER_62_159 VDD VDD VSS VSS gf180mcu_fd_sc_mcu7t5v0__fillcap_4
XTAP_TAPCELL_ROW_73_688 VDD VSS gf180mcu_fd_sc_mcu7t5v0__filltie
Xhold208 _4116_/Q hold208/Z VDD VDD VSS VSS gf180mcu_fd_sc_mcu7t5v0__dlyc_1
Xhold219 _3976_/Q _1969_/I VDD VDD VSS VSS gf180mcu_fd_sc_mcu7t5v0__dlyc_1
X_3400_ _3393_/B _3400_/A2 _3547_/B _3401_/I VDD VDD VSS VSS gf180mcu_fd_sc_mcu7t5v0__oai21_1
X_3331_ _3395_/A1 _3331_/A2 _3330_/Z _4050_/D VDD VDD VSS VSS gf180mcu_fd_sc_mcu7t5v0__nor3_1
XFILLER_112_367 VDD VDD VSS VSS gf180mcu_fd_sc_mcu7t5v0__fill_1
Xtop_level_98 i2c_sda_out_sl_control VDD VDD VSS VSS gf180mcu_fd_sc_mcu7t5v0__tiel
X_3262_ _3262_/A1 _3274_/A2 _3262_/B _4024_/D VDD VDD VSS VSS gf180mcu_fd_sc_mcu7t5v0__aoi21_1
XFILLER_22_2 VDD VDD VSS VSS gf180mcu_fd_sc_mcu7t5v0__fillcap_16
X_2213_ _3791_/Q _2111_/Z _3746_/B _2214_/A2 VDD VDD VSS VSS gf180mcu_fd_sc_mcu7t5v0__oai21_1
X_3193_ _3750_/I1 _3206_/A2 wire81/Z _3194_/B VDD VDD VSS VSS gf180mcu_fd_sc_mcu7t5v0__oai21_1
X_2144_ _3768_/Q _2243_/A2 _3746_/B _2145_/A2 VDD VDD VSS VSS gf180mcu_fd_sc_mcu7t5v0__oai21_1
XFILLER_26_307 VDD VDD VSS VSS gf180mcu_fd_sc_mcu7t5v0__fillcap_8
X_2075_ _2075_/I _2490_/A1 VDD VDD VSS VSS gf180mcu_fd_sc_mcu7t5v0__clkinv_1
X_2977_ _2977_/A1 _2977_/A2 _2977_/A3 _2977_/A4 _2978_/B2 VDD VDD VSS VSS gf180mcu_fd_sc_mcu7t5v0__nand4_1
X_1928_ _4017_/Q _3247_/A1 VDD VDD VSS VSS gf180mcu_fd_sc_mcu7t5v0__clkinv_1
X_3529_ _3536_/A2 _3525_/Z _4096_/Q _3530_/B VDD VDD VSS VSS gf180mcu_fd_sc_mcu7t5v0__aoi21_1
XFILLER_29_112 VDD VDD VSS VSS gf180mcu_fd_sc_mcu7t5v0__fill_2
XFILLER_69_270 VDD VDD VSS VSS gf180mcu_fd_sc_mcu7t5v0__fill_1
XTAP_TAPCELL_ROW_4_277 VDD VSS gf180mcu_fd_sc_mcu7t5v0__filltie
XFILLER_55_68 VDD VDD VSS VSS gf180mcu_fd_sc_mcu7t5v0__fill_2
XTAP_TAPCELL_ROW_107_892 VDD VSS gf180mcu_fd_sc_mcu7t5v0__filltie
XFILLER_52_192 VDD VDD VSS VSS gf180mcu_fd_sc_mcu7t5v0__fill_1
XFILLER_52_181 VDD VDD VSS VSS gf180mcu_fd_sc_mcu7t5v0__fill_2
XFILLER_40_387 VDD VDD VSS VSS gf180mcu_fd_sc_mcu7t5v0__fill_1
XFILLER_4_200 VDD VDD VSS VSS gf180mcu_fd_sc_mcu7t5v0__fillcap_4
XFILLER_20_60 VDD VDD VSS VSS gf180mcu_fd_sc_mcu7t5v0__fill_1
XFILLER_20_93 VDD VDD VSS VSS gf180mcu_fd_sc_mcu7t5v0__fill_2
XFILLER_106_172 VDD VDD VSS VSS gf180mcu_fd_sc_mcu7t5v0__fill_2
XFILLER_90_243 VDD VDD VSS VSS gf180mcu_fd_sc_mcu7t5v0__fill_2
XFILLER_50_107 VDD VDD VSS VSS gf180mcu_fd_sc_mcu7t5v0__fillcap_16
X_2900_ _2908_/A1 _2899_/Z _2901_/A2 VDD VDD VSS VSS gf180mcu_fd_sc_mcu7t5v0__xnor2_1
X_3880_ _3880_/D clkload6/I _3880_/Q VDD VDD VSS VSS gf180mcu_fd_sc_mcu7t5v0__dffq_1
X_2831_ _3963_/Q _3905_/Q _2831_/Z VDD VDD VSS VSS gf180mcu_fd_sc_mcu7t5v0__xor2_1
X_2762_ _2762_/I _2765_/A1 VDD VDD VSS VSS gf180mcu_fd_sc_mcu7t5v0__clkinv_1
X_2693_ _2693_/A1 _2693_/A2 _2694_/B VDD VDD VSS VSS gf180mcu_fd_sc_mcu7t5v0__nand2_1
XFILLER_6_62 VDD VDD VSS VSS gf180mcu_fd_sc_mcu7t5v0__fill_1
XFILLER_6_84 VDD VDD VSS VSS gf180mcu_fd_sc_mcu7t5v0__fillcap_4
XFILLER_112_120 VDD VDD VSS VSS gf180mcu_fd_sc_mcu7t5v0__fill_1
X_3314_ _4045_/Q _3310_/Z _3316_/A2 VDD VDD VSS VSS gf180mcu_fd_sc_mcu7t5v0__nor2_1
X_3245_ _3245_/A1 _3257_/A2 _3245_/B _4016_/D VDD VDD VSS VSS gf180mcu_fd_sc_mcu7t5v0__aoi21_1
XFILLER_98_387 VDD VDD VSS VSS gf180mcu_fd_sc_mcu7t5v0__fill_2
XFILLER_112_197 VDD VDD VSS VSS gf180mcu_fd_sc_mcu7t5v0__fill_2
XFILLER_100_348 VDD VDD VSS VSS gf180mcu_fd_sc_mcu7t5v0__fill_2
X_3176_ _3848_/Q wire44/Z wire81/I _3177_/B VDD VDD VSS VSS gf180mcu_fd_sc_mcu7t5v0__oai21_1
XTAP_TAPCELL_ROW_1_258 VDD VSS gf180mcu_fd_sc_mcu7t5v0__filltie
XFILLER_54_424 VDD VDD VSS VSS gf180mcu_fd_sc_mcu7t5v0__fill_2
XFILLER_66_273 VDD VDD VSS VSS gf180mcu_fd_sc_mcu7t5v0__fillcap_4
X_2127_ _2127_/A1 _2127_/A2 _3762_/D VDD VDD VSS VSS gf180mcu_fd_sc_mcu7t5v0__nor2_1
X_2058_ _3900_/Q _2640_/A2 VDD VDD VSS VSS gf180mcu_fd_sc_mcu7t5v0__clkinv_1
XFILLER_22_387 VDD VDD VSS VSS gf180mcu_fd_sc_mcu7t5v0__fillcap_32
XFILLER_1_203 VDD VDD VSS VSS gf180mcu_fd_sc_mcu7t5v0__fillcap_4
XFILLER_1_236 VDD VDD VSS VSS gf180mcu_fd_sc_mcu7t5v0__fill_2
XFILLER_89_354 VDD VDD VSS VSS gf180mcu_fd_sc_mcu7t5v0__fill_1
XFILLER_66_34 VDD VDD VSS VSS gf180mcu_fd_sc_mcu7t5v0__fill_1
XFILLER_66_67 VDD VDD VSS VSS gf180mcu_fd_sc_mcu7t5v0__fillcap_32
XFILLER_17_148 VDD VDD VSS VSS gf180mcu_fd_sc_mcu7t5v0__fillcap_16
XTAP_TAPCELL_ROW_83_750 VDD VSS gf180mcu_fd_sc_mcu7t5v0__filltie
XFILLER_32_107 VDD VDD VSS VSS gf180mcu_fd_sc_mcu7t5v0__fill_1
XFILLER_15_82 VDD VDD VSS VSS gf180mcu_fd_sc_mcu7t5v0__fill_1
XTAP_TAPCELL_ROW_23_393 VDD VSS gf180mcu_fd_sc_mcu7t5v0__filltie
X_3030_ _3030_/A1 _3030_/A2 _3030_/A3 _3030_/A4 _3031_/C VDD VDD VSS VSS gf180mcu_fd_sc_mcu7t5v0__nand4_1
XFILLER_51_416 VDD VDD VSS VSS gf180mcu_fd_sc_mcu7t5v0__fillcap_4
XFILLER_63_265 VDD VDD VSS VSS gf180mcu_fd_sc_mcu7t5v0__fillcap_8
X_3932_ _3932_/D _4169_/CLK _3932_/Q VDD VDD VSS VSS gf180mcu_fd_sc_mcu7t5v0__dffq_1
X_3863_ _3863_/D clkload2/I _3863_/Q VDD VDD VSS VSS gf180mcu_fd_sc_mcu7t5v0__dffq_1
X_2814_ _3126_/A1 _3902_/Q _2814_/Z VDD VDD VSS VSS gf180mcu_fd_sc_mcu7t5v0__xor2_1
XFILLER_31_173 VDD VDD VSS VSS gf180mcu_fd_sc_mcu7t5v0__fillcap_4
XFILLER_117_201 VDD VDD VSS VSS gf180mcu_fd_sc_mcu7t5v0__fill_1
X_3794_ _3794_/D clkload3/I _3794_/Q VDD VDD VSS VSS gf180mcu_fd_sc_mcu7t5v0__dffq_1
XFILLER_117_212 VDD VDD VSS VSS gf180mcu_fd_sc_mcu7t5v0__fill_2
X_2745_ _2760_/C _2744_/Z _3892_/D VDD VDD VSS VSS gf180mcu_fd_sc_mcu7t5v0__nor2_1
X_2676_ _2691_/B _2696_/A3 _2677_/C VDD VDD VSS VSS gf180mcu_fd_sc_mcu7t5v0__nand2_1
XFILLER_98_140 VDD VDD VSS VSS gf180mcu_fd_sc_mcu7t5v0__fillcap_16
XFILLER_100_123 VDD VDD VSS VSS gf180mcu_fd_sc_mcu7t5v0__fillcap_4
X_3228_ _3228_/A1 _3240_/A2 _3228_/B _4008_/D VDD VDD VSS VSS gf180mcu_fd_sc_mcu7t5v0__aoi21_1
XFILLER_36_26 VDD VDD VSS VSS gf180mcu_fd_sc_mcu7t5v0__fill_1
X_3159_ _3848_/Q _3170_/A2 wire81/I _3160_/B VDD VDD VSS VSS gf180mcu_fd_sc_mcu7t5v0__oai21_1
XFILLER_100_189 VDD VDD VSS VSS gf180mcu_fd_sc_mcu7t5v0__fill_2
XFILLER_14_107 VDD VDD VSS VSS gf180mcu_fd_sc_mcu7t5v0__fillcap_64
XTAP_TAPCELL_ROW_37_474 VDD VSS gf180mcu_fd_sc_mcu7t5v0__filltie
XFILLER_54_276 VDD VDD VSS VSS gf180mcu_fd_sc_mcu7t5v0__fillcap_8
XTAP_TAPCELL_ROW_80_731 VDD VSS gf180mcu_fd_sc_mcu7t5v0__filltie
XFILLER_22_195 VDD VDD VSS VSS gf180mcu_fd_sc_mcu7t5v0__fill_1
XFILLER_6_317 VDD VDD VSS VSS gf180mcu_fd_sc_mcu7t5v0__fillcap_64
XTAP_TAPCELL_ROW_20_374 VDD VSS gf180mcu_fd_sc_mcu7t5v0__filltie
XFILLER_108_234 VDD VDD VSS VSS gf180mcu_fd_sc_mcu7t5v0__fill_2
X_2530_ _3874_/Q _2546_/B _2548_/A2 _3810_/Q _2531_/B VDD VDD VSS VSS gf180mcu_fd_sc_mcu7t5v0__aoi22_1
X_2461_ _3872_/Q _2461_/A2 _2499_/A2 VDD VDD VSS VSS gf180mcu_fd_sc_mcu7t5v0__nand2_1
XPHY_EDGE_ROW_39_Left_161 VDD VSS gf180mcu_fd_sc_mcu7t5v0__endcap
X_4200_ _4200_/I _4200_/Z VDD VDD VSS VSS gf180mcu_fd_sc_mcu7t5v0__buf_1
X_2392_ _3874_/Q _2396_/A2 _2400_/B1 _3840_/Q _2393_/I VDD VDD VSS VSS gf180mcu_fd_sc_mcu7t5v0__aoi22_1
XFILLER_68_313 VDD VDD VSS VSS gf180mcu_fd_sc_mcu7t5v0__fill_2
X_4131_ _4131_/D _4155_/CLK _4131_/Q VDD VDD VSS VSS gf180mcu_fd_sc_mcu7t5v0__dffq_1
XFILLER_68_368 VDD VDD VSS VSS gf180mcu_fd_sc_mcu7t5v0__fill_2
X_4062_ _4062_/D _4104_/CLK _4062_/Q VDD VDD VSS VSS gf180mcu_fd_sc_mcu7t5v0__dffq_1
X_3013_ _3990_/Q _3173_/A1 _3013_/B1 _3998_/Q _3016_/A1 VDD VDD VSS VSS gf180mcu_fd_sc_mcu7t5v0__aoi22_1
XPHY_EDGE_ROW_48_Left_170 VDD VSS gf180mcu_fd_sc_mcu7t5v0__endcap
XFILLER_51_235 VDD VDD VSS VSS gf180mcu_fd_sc_mcu7t5v0__fill_1
Xclkbuf_1_1__f_signal_input clkbuf_0_signal_input/Z _4164_/D VDD VDD VSS VSS gf180mcu_fd_sc_mcu7t5v0__clkbuf_16
XTAP_TAPCELL_ROW_34_455 VDD VSS gf180mcu_fd_sc_mcu7t5v0__filltie
X_3915_ _3915_/D _4169_/CLK _3915_/Q VDD VDD VSS VSS gf180mcu_fd_sc_mcu7t5v0__dffq_1
XFILLER_22_28 VDD VDD VSS VSS gf180mcu_fd_sc_mcu7t5v0__fill_1
X_3846_ _3846_/D clkload7/I _3846_/Q VDD VDD VSS VSS gf180mcu_fd_sc_mcu7t5v0__dffq_1
X_3777_ _3777_/D _4058_/CLK _3777_/Q VDD VDD VSS VSS gf180mcu_fd_sc_mcu7t5v0__dffq_1
X_2728_ _2726_/Z _2728_/A2 _2728_/Z VDD VDD VSS VSS gf180mcu_fd_sc_mcu7t5v0__xor2_1
X_2659_ _3262_/A1 _3902_/Q _3901_/Q _3260_/A1 _2686_/A2 VDD VDD VSS VSS gf180mcu_fd_sc_mcu7t5v0__aoi22_1
XFILLER_120_207 VDD VDD VSS VSS gf180mcu_fd_sc_mcu7t5v0__fill_2
XFILLER_59_346 VDD VDD VSS VSS gf180mcu_fd_sc_mcu7t5v0__fillcap_4
XFILLER_47_36 VDD VDD VSS VSS gf180mcu_fd_sc_mcu7t5v0__fill_2
XPHY_EDGE_ROW_114_Right_114 VDD VSS gf180mcu_fd_sc_mcu7t5v0__endcap
XFILLER_27_276 VDD VDD VSS VSS gf180mcu_fd_sc_mcu7t5v0__fillcap_4
XFILLER_15_416 VDD VDD VSS VSS gf180mcu_fd_sc_mcu7t5v0__fillcap_4
XFILLER_42_202 VDD VDD VSS VSS gf180mcu_fd_sc_mcu7t5v0__fill_1
XFILLER_103_64 VDD VDD VSS VSS gf180mcu_fd_sc_mcu7t5v0__fill_1
XTAP_TAPCELL_ROW_112_927 VDD VSS gf180mcu_fd_sc_mcu7t5v0__filltie
XTAP_TAPCELL_ROW_25_400 VDD VSS gf180mcu_fd_sc_mcu7t5v0__filltie
XTAP_TAPCELL_ROW_120_971 VDD VSS gf180mcu_fd_sc_mcu7t5v0__filltie
XFILLER_77_187 VDD VDD VSS VSS gf180mcu_fd_sc_mcu7t5v0__fill_2
XFILLER_92_124 VDD VDD VSS VSS gf180mcu_fd_sc_mcu7t5v0__fillcap_8
XFILLER_33_224 VDD VDD VSS VSS gf180mcu_fd_sc_mcu7t5v0__fillcap_8
XTAP_TAPCELL_ROW_56_591 VDD VSS gf180mcu_fd_sc_mcu7t5v0__filltie
XFILLER_73_393 VDD VDD VSS VSS gf180mcu_fd_sc_mcu7t5v0__fill_2
XFILLER_21_419 VDD VDD VSS VSS gf180mcu_fd_sc_mcu7t5v0__fill_1
X_1961_ _3984_/Q _3177_/A1 VDD VDD VSS VSS gf180mcu_fd_sc_mcu7t5v0__clkinv_1
X_3700_ _3700_/A1 _3748_/A2 _3717_/A2 VDD VDD VSS VSS gf180mcu_fd_sc_mcu7t5v0__nand2_1
XTAP_TAPCELL_ROW_31_436 VDD VSS gf180mcu_fd_sc_mcu7t5v0__filltie
X_1892_ _4098_/Q _3536_/A1 VDD VDD VSS VSS gf180mcu_fd_sc_mcu7t5v0__clkinv_1
X_3631_ hold159/Z _3669_/A2 _3650_/B1 _3631_/B2 _3632_/A2 VDD VDD VSS VSS gf180mcu_fd_sc_mcu7t5v0__aoi22_1
X_3562_ _4142_/Q _3566_/B _3582_/A2 VDD VDD VSS VSS gf180mcu_fd_sc_mcu7t5v0__nand2_1
X_2513_ _2510_/B _2506_/Z _2543_/A2 VDD VDD VSS VSS gf180mcu_fd_sc_mcu7t5v0__nand2_1
XFILLER_52_2 VDD VDD VSS VSS gf180mcu_fd_sc_mcu7t5v0__fillcap_16
X_3493_ _4087_/Q _3498_/A2 _3536_/A2 _3493_/B2 _3495_/A1 VDD VDD VSS VSS gf180mcu_fd_sc_mcu7t5v0__aoi22_1
X_2444_ _2536_/A1 _2430_/Z _2444_/B _3859_/D VDD VDD VSS VSS gf180mcu_fd_sc_mcu7t5v0__aoi21_1
X_2375_ hold128/Z _3256_/B _3834_/D VDD VDD VSS VSS gf180mcu_fd_sc_mcu7t5v0__and2_1
XFILLER_68_121 VDD VDD VSS VSS gf180mcu_fd_sc_mcu7t5v0__fill_1
X_4114_ _4114_/D _4149_/CLK _4114_/Q VDD VDD VSS VSS gf180mcu_fd_sc_mcu7t5v0__dffq_1
XFILLER_68_165 VDD VDD VSS VSS gf180mcu_fd_sc_mcu7t5v0__fill_2
X_4045_ _4045_/D _4052_/CLK _4045_/Q VDD VDD VSS VSS gf180mcu_fd_sc_mcu7t5v0__dffq_1
XFILLER_83_179 VDD VDD VSS VSS gf180mcu_fd_sc_mcu7t5v0__fill_1
XFILLER_91_190 VDD VDD VSS VSS gf180mcu_fd_sc_mcu7t5v0__fillcap_4
XFILLER_12_419 VDD VDD VSS VSS gf180mcu_fd_sc_mcu7t5v0__fillcap_4
X_3829_ _3829_/D clkload8/I _3829_/Q VDD VDD VSS VSS gf180mcu_fd_sc_mcu7t5v0__dffq_1
XFILLER_118_362 VDD VDD VSS VSS gf180mcu_fd_sc_mcu7t5v0__fillcap_4
XFILLER_118_384 VDD VDD VSS VSS gf180mcu_fd_sc_mcu7t5v0__fill_1
XFILLER_3_139 VDD VDD VSS VSS gf180mcu_fd_sc_mcu7t5v0__fill_1
XFILLER_59_198 VDD VDD VSS VSS gf180mcu_fd_sc_mcu7t5v0__fillcap_4
XFILLER_74_34 VDD VDD VSS VSS gf180mcu_fd_sc_mcu7t5v0__fill_1
XFILLER_74_89 VDD VDD VSS VSS gf180mcu_fd_sc_mcu7t5v0__fillcap_16
XFILLER_15_279 VDD VDD VSS VSS gf180mcu_fd_sc_mcu7t5v0__fill_1
XTAP_TAPCELL_ROW_53_572 VDD VSS gf180mcu_fd_sc_mcu7t5v0__filltie
XFILLER_90_88 VDD VDD VSS VSS gf180mcu_fd_sc_mcu7t5v0__fill_1
XFILLER_93_422 VDD VDD VSS VSS gf180mcu_fd_sc_mcu7t5v0__fillcap_4
X_2160_ _2160_/A1 _2160_/A2 _3773_/D VDD VDD VSS VSS gf180mcu_fd_sc_mcu7t5v0__nor2_1
XFILLER_65_135 VDD VDD VSS VSS gf180mcu_fd_sc_mcu7t5v0__fillcap_4
X_2091_ _4104_/Q _2091_/A2 _2091_/B _2092_/I VDD VDD VSS VSS gf180mcu_fd_sc_mcu7t5v0__oai21_1
XFILLER_0_64 VDD VDD VSS VSS gf180mcu_fd_sc_mcu7t5v0__fillcap_4
XFILLER_80_149 VDD VDD VSS VSS gf180mcu_fd_sc_mcu7t5v0__fillcap_4
XFILLER_61_352 VDD VDD VSS VSS gf180mcu_fd_sc_mcu7t5v0__fillcap_4
X_2993_ _3964_/Q _3036_/B1 _3088_/A1 _3948_/Q _3015_/C1 _3972_/Q _2998_/A2 VDD VDD
+ VSS VSS gf180mcu_fd_sc_mcu7t5v0__aoi222_1
X_1944_ _1944_/I _3213_/A1 VDD VDD VSS VSS gf180mcu_fd_sc_mcu7t5v0__clkinv_1
X_3614_ _3731_/C _3614_/A2 _4115_/D VDD VDD VSS VSS gf180mcu_fd_sc_mcu7t5v0__nor2_1
X_3545_ _4103_/Q _3538_/B _3545_/A3 _4103_/D VDD VDD VSS VSS gf180mcu_fd_sc_mcu7t5v0__and3_1
X_3476_ _4083_/Q _3479_/A2 _3549_/B _3476_/B2 _3477_/A2 VDD VDD VSS VSS gf180mcu_fd_sc_mcu7t5v0__aoi22_1
X_2427_ _2459_/A1 _3815_/Q _2427_/Z VDD VDD VSS VSS gf180mcu_fd_sc_mcu7t5v0__or2_1
XTAP_TAPCELL_ROW_59_609 VDD VSS gf180mcu_fd_sc_mcu7t5v0__filltie
X_2358_ _2360_/A1 _2358_/A2 _2358_/Z VDD VDD VSS VSS gf180mcu_fd_sc_mcu7t5v0__xor2_1
X_2289_ _2333_/B _2289_/A2 _2349_/B _3834_/Q _2290_/A3 VDD VDD VSS VSS gf180mcu_fd_sc_mcu7t5v0__oai22_1
XTAP_TAPCELL_ROW_67_653 VDD VSS gf180mcu_fd_sc_mcu7t5v0__filltie
X_4028_ _4028_/D _4155_/CLK _4028_/Q VDD VDD VSS VSS gf180mcu_fd_sc_mcu7t5v0__dffq_1
XFILLER_44_37 VDD VDD VSS VSS gf180mcu_fd_sc_mcu7t5v0__fillcap_32
XTAP_TAPCELL_ROW_50_553 VDD VSS gf180mcu_fd_sc_mcu7t5v0__filltie
XFILLER_118_181 VDD VDD VSS VSS gf180mcu_fd_sc_mcu7t5v0__fill_2
XFILLER_106_310 VDD VDD VSS VSS gf180mcu_fd_sc_mcu7t5v0__fillcap_4
XFILLER_106_387 VDD VDD VSS VSS gf180mcu_fd_sc_mcu7t5v0__fillcap_32
XTAP_TAPCELL_ROW_7_297 VDD VSS gf180mcu_fd_sc_mcu7t5v0__filltie
XFILLER_75_411 VDD VDD VSS VSS gf180mcu_fd_sc_mcu7t5v0__fill_1
XFILLER_75_422 VDD VDD VSS VSS gf180mcu_fd_sc_mcu7t5v0__fillcap_4
XFILLER_28_382 VDD VDD VSS VSS gf180mcu_fd_sc_mcu7t5v0__fill_2
Xdelaybuf_1_signal_clock delaybuf_1_signal_clock/I delaybuf_2_signal_clock/I VDD VDD
+ VSS VSS gf180mcu_fd_sc_mcu7t5v0__clkbuf_16
XFILLER_43_352 VDD VDD VSS VSS gf180mcu_fd_sc_mcu7t5v0__fill_1
XFILLER_62_149 VDD VDD VSS VSS gf180mcu_fd_sc_mcu7t5v0__fill_2
XTAP_TAPCELL_ROW_73_689 VDD VSS gf180mcu_fd_sc_mcu7t5v0__filltie
XFILLER_70_193 VDD VDD VSS VSS gf180mcu_fd_sc_mcu7t5v0__fill_2
XFILLER_11_271 VDD VDD VSS VSS gf180mcu_fd_sc_mcu7t5v0__fill_1
XFILLER_116_107 VDD VDD VSS VSS gf180mcu_fd_sc_mcu7t5v0__fill_2
Xhold209 _3778_/Q hold209/Z VDD VDD VSS VSS gf180mcu_fd_sc_mcu7t5v0__dlyc_1
X_3330_ _4050_/Q _4049_/Q _4048_/Q _3321_/Z _3330_/Z VDD VDD VSS VSS gf180mcu_fd_sc_mcu7t5v0__and4_1
XFILLER_112_313 VDD VDD VSS VSS gf180mcu_fd_sc_mcu7t5v0__fill_2
Xtop_level_99 nrst_in_pd_control VDD VDD VSS VSS gf180mcu_fd_sc_mcu7t5v0__tiel
X_3261_ _3750_/I1 _3274_/A2 wire81/Z _3262_/B VDD VDD VSS VSS gf180mcu_fd_sc_mcu7t5v0__oai21_1
X_2212_ _4089_/Q _2248_/A2 _2214_/A1 VDD VDD VSS VSS gf180mcu_fd_sc_mcu7t5v0__nor2_1
X_3192_ _3192_/A1 _3206_/A2 _3192_/B _3991_/D VDD VDD VSS VSS gf180mcu_fd_sc_mcu7t5v0__aoi21_1
X_2143_ _4049_/Q _2155_/A2 _2145_/A1 VDD VDD VSS VSS gf180mcu_fd_sc_mcu7t5v0__nor2_1
XFILLER_15_2 VDD VDD VSS VSS gf180mcu_fd_sc_mcu7t5v0__fillcap_16
XFILLER_93_230 VDD VDD VSS VSS gf180mcu_fd_sc_mcu7t5v0__fill_2
XFILLER_53_116 VDD VDD VSS VSS gf180mcu_fd_sc_mcu7t5v0__fillcap_16
XTAP_TAPCELL_ROW_64_634 VDD VSS gf180mcu_fd_sc_mcu7t5v0__filltie
X_2074_ _4164_/Q _3454_/A2 VDD VDD VSS VSS gf180mcu_fd_sc_mcu7t5v0__clkinv_1
X_2976_ _3978_/Q _2987_/B1 _3088_/A1 _3946_/Q _2977_/A4 VDD VDD VSS VSS gf180mcu_fd_sc_mcu7t5v0__aoi22_1
X_1927_ _4018_/Q _3249_/A1 VDD VDD VSS VSS gf180mcu_fd_sc_mcu7t5v0__clkinv_1
X_3528_ _3552_/C _3528_/A2 _3528_/A3 _4095_/D VDD VDD VSS VSS gf180mcu_fd_sc_mcu7t5v0__nor3_1
X_3459_ _4147_/Q _3455_/Z _3458_/I _3459_/ZN VDD VDD VSS VSS gf180mcu_fd_sc_mcu7t5v0__nand3_1
XFILLER_57_422 VDD VDD VSS VSS gf180mcu_fd_sc_mcu7t5v0__fillcap_4
XFILLER_69_293 VDD VDD VSS VSS gf180mcu_fd_sc_mcu7t5v0__fillcap_8
XTAP_TAPCELL_ROW_4_278 VDD VSS gf180mcu_fd_sc_mcu7t5v0__filltie
XFILLER_29_146 VDD VDD VSS VSS gf180mcu_fd_sc_mcu7t5v0__fillcap_32
XFILLER_55_25 VDD VDD VSS VSS gf180mcu_fd_sc_mcu7t5v0__fill_2
XFILLER_72_425 VDD VDD VSS VSS gf180mcu_fd_sc_mcu7t5v0__fill_1
XFILLER_25_352 VDD VDD VSS VSS gf180mcu_fd_sc_mcu7t5v0__fillcap_64
XTAP_TAPCELL_ROW_107_893 VDD VSS gf180mcu_fd_sc_mcu7t5v0__filltie
XFILLER_71_68 VDD VDD VSS VSS gf180mcu_fd_sc_mcu7t5v0__fill_2
XFILLER_4_256 VDD VDD VSS VSS gf180mcu_fd_sc_mcu7t5v0__fill_2
XFILLER_96_21 VDD VDD VSS VSS gf180mcu_fd_sc_mcu7t5v0__fillcap_8
XFILLER_121_165 VDD VDD VSS VSS gf180mcu_fd_sc_mcu7t5v0__fillcap_4
XFILLER_48_422 VDD VDD VSS VSS gf180mcu_fd_sc_mcu7t5v0__fillcap_4
XFILLER_96_98 VDD VDD VSS VSS gf180mcu_fd_sc_mcu7t5v0__fillcap_4
XFILLER_35_138 VDD VDD VSS VSS gf180mcu_fd_sc_mcu7t5v0__fill_2
XTAP_TAPCELL_ROW_86_770 VDD VSS gf180mcu_fd_sc_mcu7t5v0__filltie
XTAP_TAPCELL_ROW_18_358 VDD VSS gf180mcu_fd_sc_mcu7t5v0__filltie
XPHY_EDGE_ROW_11_Left_133 VDD VSS gf180mcu_fd_sc_mcu7t5v0__endcap
X_2830_ _2929_/A1 _2829_/Z _3904_/D VDD VDD VSS VSS gf180mcu_fd_sc_mcu7t5v0__nor2_1
X_2761_ _3953_/Q _3895_/Q _2762_/I VDD VDD VSS VSS gf180mcu_fd_sc_mcu7t5v0__xor2_1
X_2692_ _2692_/A1 _2692_/A2 _2692_/B _2694_/A2 VDD VDD VSS VSS gf180mcu_fd_sc_mcu7t5v0__aoi21_1
XPHY_EDGE_ROW_20_Left_142 VDD VSS gf180mcu_fd_sc_mcu7t5v0__endcap
X_3313_ _3313_/I _4044_/D VDD VDD VSS VSS gf180mcu_fd_sc_mcu7t5v0__clkinv_1
X_3244_ _3848_/Q _3257_/A2 _3256_/B _3245_/B VDD VDD VSS VSS gf180mcu_fd_sc_mcu7t5v0__oai21_1
XFILLER_39_422 VDD VDD VSS VSS gf180mcu_fd_sc_mcu7t5v0__fillcap_4
X_3175_ _3175_/A1 wire44/Z _3175_/B _3983_/D VDD VDD VSS VSS gf180mcu_fd_sc_mcu7t5v0__aoi21_1
X_2126_ _3762_/Q _2243_/A2 _3746_/B _2127_/A2 VDD VDD VSS VSS gf180mcu_fd_sc_mcu7t5v0__oai21_1
X_2057_ _3903_/Q _2687_/B VDD VDD VSS VSS gf180mcu_fd_sc_mcu7t5v0__clkinv_1
XTAP_TAPCELL_ROW_1_259 VDD VSS gf180mcu_fd_sc_mcu7t5v0__filltie
XFILLER_81_277 VDD VDD VSS VSS gf180mcu_fd_sc_mcu7t5v0__fill_2
XFILLER_34_182 VDD VDD VSS VSS gf180mcu_fd_sc_mcu7t5v0__fillcap_4
XTAP_TAPCELL_ROW_104_874 VDD VSS gf180mcu_fd_sc_mcu7t5v0__filltie
X_2959_ _3977_/Q _2987_/B1 _3088_/A1 _3945_/Q _2961_/A2 VDD VDD VSS VSS gf180mcu_fd_sc_mcu7t5v0__aoi22_1
XTAP_TAPCELL_ROW_9_304 VDD VSS gf180mcu_fd_sc_mcu7t5v0__filltie
XFILLER_89_322 VDD VDD VSS VSS gf180mcu_fd_sc_mcu7t5v0__fill_2
XFILLER_57_230 VDD VDD VSS VSS gf180mcu_fd_sc_mcu7t5v0__fill_1
XFILLER_57_296 VDD VDD VSS VSS gf180mcu_fd_sc_mcu7t5v0__fillcap_4
XFILLER_72_244 VDD VDD VSS VSS gf180mcu_fd_sc_mcu7t5v0__fill_1
XTAP_TAPCELL_ROW_83_751 VDD VSS gf180mcu_fd_sc_mcu7t5v0__filltie
XFILLER_82_89 VDD VDD VSS VSS gf180mcu_fd_sc_mcu7t5v0__fill_1
XFILLER_15_72 VDD VDD VSS VSS gf180mcu_fd_sc_mcu7t5v0__fillcap_8
XFILLER_9_348 VDD VDD VSS VSS gf180mcu_fd_sc_mcu7t5v0__fill_2
XFILLER_40_174 VDD VDD VSS VSS gf180mcu_fd_sc_mcu7t5v0__fill_1
XFILLER_31_93 VDD VDD VSS VSS gf180mcu_fd_sc_mcu7t5v0__fillcap_4
XFILLER_36_403 VDD VDD VSS VSS gf180mcu_fd_sc_mcu7t5v0__fillcap_16
XFILLER_36_425 VDD VDD VSS VSS gf180mcu_fd_sc_mcu7t5v0__fill_1
XFILLER_63_244 VDD VDD VSS VSS gf180mcu_fd_sc_mcu7t5v0__fillcap_8
XFILLER_23_108 VDD VDD VSS VSS gf180mcu_fd_sc_mcu7t5v0__fillcap_4
X_3931_ _3931_/D _4170_/CLK _3931_/Q VDD VDD VSS VSS gf180mcu_fd_sc_mcu7t5v0__dffq_1
X_3862_ _3862_/D clkload6/I _3862_/Q VDD VDD VSS VSS gf180mcu_fd_sc_mcu7t5v0__dffq_1
XFILLER_31_152 VDD VDD VSS VSS gf180mcu_fd_sc_mcu7t5v0__fill_1
X_2813_ _3960_/Q _3902_/Q _2821_/B VDD VDD VSS VSS gf180mcu_fd_sc_mcu7t5v0__nand2_1
XFILLER_82_2 VDD VDD VSS VSS gf180mcu_fd_sc_mcu7t5v0__fill_1
X_3793_ _3793_/D clkload4/I _3793_/Q VDD VDD VSS VSS gf180mcu_fd_sc_mcu7t5v0__dffq_1
X_2744_ _2744_/A1 _2744_/A2 _2744_/Z VDD VDD VSS VSS gf180mcu_fd_sc_mcu7t5v0__xor2_1
XFILLER_8_381 VDD VDD VSS VSS gf180mcu_fd_sc_mcu7t5v0__fillcap_4
X_2675_ _2675_/A1 _2675_/A2 _2693_/A2 _2684_/B _2694_/A1 VDD VDD VSS VSS gf180mcu_fd_sc_mcu7t5v0__nand4_1
XFILLER_105_419 VDD VDD VSS VSS gf180mcu_fd_sc_mcu7t5v0__fill_1
XFILLER_86_314 VDD VDD VSS VSS gf180mcu_fd_sc_mcu7t5v0__fill_1
XFILLER_98_174 VDD VDD VSS VSS gf180mcu_fd_sc_mcu7t5v0__fill_1
XTAP_TAPCELL_ROW_97_832 VDD VSS gf180mcu_fd_sc_mcu7t5v0__filltie
XFILLER_98_185 VDD VDD VSS VSS gf180mcu_fd_sc_mcu7t5v0__fill_2
X_3227_ _3848_/Q _3240_/A2 wire81/I _3228_/B VDD VDD VSS VSS gf180mcu_fd_sc_mcu7t5v0__oai21_1
X_3158_ _3158_/A1 _3170_/A2 _3158_/B _3975_/D VDD VDD VSS VSS gf180mcu_fd_sc_mcu7t5v0__aoi21_1
XFILLER_54_244 VDD VDD VSS VSS gf180mcu_fd_sc_mcu7t5v0__fill_1
X_2109_ _3674_/B _3675_/A2 _2110_/A2 VDD VDD VSS VSS gf180mcu_fd_sc_mcu7t5v0__nand2_1
XTAP_TAPCELL_ROW_37_475 VDD VSS gf180mcu_fd_sc_mcu7t5v0__filltie
X_3089_ wire94/I _3090_/A2 wire81/I _3090_/B VDD VDD VSS VSS gf180mcu_fd_sc_mcu7t5v0__oai21_1
XFILLER_54_288 VDD VDD VSS VSS gf180mcu_fd_sc_mcu7t5v0__fill_2
XTAP_TAPCELL_ROW_80_732 VDD VSS gf180mcu_fd_sc_mcu7t5v0__filltie
XFILLER_22_152 VDD VDD VSS VSS gf180mcu_fd_sc_mcu7t5v0__fillcap_16
XFILLER_52_26 VDD VDD VSS VSS gf180mcu_fd_sc_mcu7t5v0__fill_1
XFILLER_52_37 VDD VDD VSS VSS gf180mcu_fd_sc_mcu7t5v0__fill_2
XFILLER_22_174 VDD VDD VSS VSS gf180mcu_fd_sc_mcu7t5v0__fill_1
XFILLER_10_303 VDD VDD VSS VSS gf180mcu_fd_sc_mcu7t5v0__fillcap_8
XTAP_TAPCELL_ROW_20_375 VDD VSS gf180mcu_fd_sc_mcu7t5v0__filltie
XFILLER_117_85 VDD VDD VSS VSS gf180mcu_fd_sc_mcu7t5v0__fill_2
XFILLER_18_425 VDD VDD VSS VSS gf180mcu_fd_sc_mcu7t5v0__fill_1
XFILLER_92_317 VDD VDD VSS VSS gf180mcu_fd_sc_mcu7t5v0__fill_1
XFILLER_93_22 VDD VDD VSS VSS gf180mcu_fd_sc_mcu7t5v0__fill_2
XTAP_TAPCELL_ROW_28_420 VDD VSS gf180mcu_fd_sc_mcu7t5v0__filltie
XFILLER_33_406 VDD VDD VSS VSS gf180mcu_fd_sc_mcu7t5v0__fillcap_8
XFILLER_60_258 VDD VDD VSS VSS gf180mcu_fd_sc_mcu7t5v0__fillcap_4
XTAP_TAPCELL_ROW_11_320 VDD VSS gf180mcu_fd_sc_mcu7t5v0__filltie
XFILLER_114_227 VDD VDD VSS VSS gf180mcu_fd_sc_mcu7t5v0__fillcap_4
X_2460_ _4157_/Q _2549_/C _2465_/B VDD VDD VSS VSS gf180mcu_fd_sc_mcu7t5v0__nor2_1
X_2391_ _2391_/I _3839_/D VDD VDD VSS VSS gf180mcu_fd_sc_mcu7t5v0__clkinv_1
X_4130_ _4130_/D _4164_/CLK _4130_/Q VDD VDD VSS VSS gf180mcu_fd_sc_mcu7t5v0__dffq_1
X_4061_ _4061_/D _4104_/CLK _4061_/Q VDD VDD VSS VSS gf180mcu_fd_sc_mcu7t5v0__dffq_1
XFILLER_95_144 VDD VDD VSS VSS gf180mcu_fd_sc_mcu7t5v0__fill_1
X_3012_ _3950_/Q _3012_/A2 _3044_/A2 _4030_/Q _3017_/A2 VDD VDD VSS VSS gf180mcu_fd_sc_mcu7t5v0__aoi22_1
XFILLER_36_244 VDD VDD VSS VSS gf180mcu_fd_sc_mcu7t5v0__fill_1
XFILLER_36_255 VDD VDD VSS VSS gf180mcu_fd_sc_mcu7t5v0__fill_2
XTAP_TAPCELL_ROW_34_456 VDD VSS gf180mcu_fd_sc_mcu7t5v0__filltie
X_3914_ _3914_/D _4169_/CLK _3914_/Q VDD VDD VSS VSS gf180mcu_fd_sc_mcu7t5v0__dffq_1
XFILLER_22_18 VDD VDD VSS VSS gf180mcu_fd_sc_mcu7t5v0__fillcap_8
X_3845_ _3845_/D _4142_/CLK _3845_/Q VDD VDD VSS VSS gf180mcu_fd_sc_mcu7t5v0__dffq_1
X_3776_ _3776_/D _4058_/CLK _3776_/Q VDD VDD VSS VSS gf180mcu_fd_sc_mcu7t5v0__dffq_1
X_2727_ _3947_/Q _3889_/Q _2727_/B _2728_/A2 VDD VDD VSS VSS gf180mcu_fd_sc_mcu7t5v0__aoi21_1
X_2658_ _2697_/A2 _2696_/A2 _2658_/A3 _2682_/A1 VDD VDD VSS VSS gf180mcu_fd_sc_mcu7t5v0__nand3_1
X_2589_ _2589_/A1 _2589_/A2 _2592_/C _2592_/A2 _2590_/C VDD VDD VSS VSS gf180mcu_fd_sc_mcu7t5v0__nand4_1
XFILLER_59_336 VDD VDD VSS VSS gf180mcu_fd_sc_mcu7t5v0__fill_1
XFILLER_101_411 VDD VDD VSS VSS gf180mcu_fd_sc_mcu7t5v0__fillcap_8
XFILLER_101_422 VDD VDD VSS VSS gf180mcu_fd_sc_mcu7t5v0__fillcap_4
XFILLER_86_177 VDD VDD VSS VSS gf180mcu_fd_sc_mcu7t5v0__fillcap_4
XTAP_TAPCELL_ROW_25_401 VDD VSS gf180mcu_fd_sc_mcu7t5v0__filltie
XFILLER_42_247 VDD VDD VSS VSS gf180mcu_fd_sc_mcu7t5v0__fillcap_4
XTAP_TAPCELL_ROW_120_972 VDD VSS gf180mcu_fd_sc_mcu7t5v0__filltie
XFILLER_6_115 VDD VDD VSS VSS gf180mcu_fd_sc_mcu7t5v0__fillcap_4
Xclkbuf_1_0__f_signal_input_regs clkbuf_0_signal_input_regs/Z _4073_/CLK VDD VDD VSS
+ VSS gf180mcu_fd_sc_mcu7t5v0__clkbuf_16
XFILLER_88_77 VDD VDD VSS VSS gf180mcu_fd_sc_mcu7t5v0__fillcap_16
XFILLER_2_387 VDD VDD VSS VSS gf180mcu_fd_sc_mcu7t5v0__fillcap_32
XFILLER_104_260 VDD VDD VSS VSS gf180mcu_fd_sc_mcu7t5v0__fillcap_8
XFILLER_18_233 VDD VDD VSS VSS gf180mcu_fd_sc_mcu7t5v0__fillcap_8
XFILLER_92_136 VDD VDD VSS VSS gf180mcu_fd_sc_mcu7t5v0__fill_2
XFILLER_21_409 VDD VDD VSS VSS gf180mcu_fd_sc_mcu7t5v0__fillcap_8
Xclkbuf_1_1__f__1538_ clkbuf_0__1538_/Z _3550_/A2 VDD VDD VSS VSS gf180mcu_fd_sc_mcu7t5v0__clkbuf_16
X_1960_ _3985_/Q _2591_/C VDD VDD VSS VSS gf180mcu_fd_sc_mcu7t5v0__clkinv_1
XFILLER_53_80 VDD VDD VSS VSS gf180mcu_fd_sc_mcu7t5v0__fillcap_4
XTAP_TAPCELL_ROW_31_437 VDD VSS gf180mcu_fd_sc_mcu7t5v0__filltie
X_1891_ _1891_/I _3453_/A1 VDD VDD VSS VSS gf180mcu_fd_sc_mcu7t5v0__clkinv_1
X_3630_ _3630_/A1 _3630_/A2 _3631_/B2 VDD VDD VSS VSS gf180mcu_fd_sc_mcu7t5v0__nand2_1
X_3561_ _3557_/B hold174/Z _3579_/B _3561_/C _4107_/D VDD VDD VSS VSS gf180mcu_fd_sc_mcu7t5v0__aoi211_1
X_2512_ _2538_/B _2538_/A1 _2548_/A2 VDD VDD VSS VSS gf180mcu_fd_sc_mcu7t5v0__nor2_1
X_3492_ _3492_/I _3493_/B2 VDD VDD VSS VSS gf180mcu_fd_sc_mcu7t5v0__clkinv_1
X_2443_ _3859_/Q _2430_/Z _3746_/B _2444_/B VDD VDD VSS VSS gf180mcu_fd_sc_mcu7t5v0__oai21_1
X_2374_ hold125/Z _3256_/B _3833_/D VDD VDD VSS VSS gf180mcu_fd_sc_mcu7t5v0__and2_1
XFILLER_96_420 VDD VDD VSS VSS gf180mcu_fd_sc_mcu7t5v0__fillcap_4
X_4113_ _4113_/D clkload5/I _4113_/Q VDD VDD VSS VSS gf180mcu_fd_sc_mcu7t5v0__dffq_1
XPHY_EDGE_ROW_3_Left_125 VDD VSS gf180mcu_fd_sc_mcu7t5v0__endcap
XFILLER_56_317 VDD VDD VSS VSS gf180mcu_fd_sc_mcu7t5v0__fillcap_4
XFILLER_68_177 VDD VDD VSS VSS gf180mcu_fd_sc_mcu7t5v0__fillcap_16
XFILLER_83_136 VDD VDD VSS VSS gf180mcu_fd_sc_mcu7t5v0__fillcap_4
X_4044_ _4044_/D _4052_/CLK _4044_/Q VDD VDD VSS VSS gf180mcu_fd_sc_mcu7t5v0__dffq_1
XFILLER_24_225 VDD VDD VSS VSS gf180mcu_fd_sc_mcu7t5v0__fillcap_8
XFILLER_24_247 VDD VDD VSS VSS gf180mcu_fd_sc_mcu7t5v0__fill_2
X_3828_ _3828_/D clkload8/I _3828_/Q VDD VDD VSS VSS gf180mcu_fd_sc_mcu7t5v0__dffq_1
X_3759_ _3759_/D _4142_/CLK _3759_/Q VDD VDD VSS VSS gf180mcu_fd_sc_mcu7t5v0__dffq_1
XFILLER_59_144 VDD VDD VSS VSS gf180mcu_fd_sc_mcu7t5v0__fill_1
XFILLER_101_230 VDD VDD VSS VSS gf180mcu_fd_sc_mcu7t5v0__fillcap_8
XFILLER_101_263 VDD VDD VSS VSS gf180mcu_fd_sc_mcu7t5v0__fillcap_4
XFILLER_15_203 VDD VDD VSS VSS gf180mcu_fd_sc_mcu7t5v0__fillcap_4
XFILLER_15_269 VDD VDD VSS VSS gf180mcu_fd_sc_mcu7t5v0__fillcap_8
XTAP_TAPCELL_ROW_53_573 VDD VSS gf180mcu_fd_sc_mcu7t5v0__filltie
XFILLER_90_34 VDD VDD VSS VSS gf180mcu_fd_sc_mcu7t5v0__fill_1
XPHY_EDGE_ROW_67_Left_189 VDD VSS gf180mcu_fd_sc_mcu7t5v0__endcap
XFILLER_23_72 VDD VDD VSS VSS gf180mcu_fd_sc_mcu7t5v0__fill_2
XFILLER_23_50 VDD VDD VSS VSS gf180mcu_fd_sc_mcu7t5v0__fill_1
XFILLER_97_206 VDD VDD VSS VSS gf180mcu_fd_sc_mcu7t5v0__fillcap_4
XFILLER_2_173 VDD VDD VSS VSS gf180mcu_fd_sc_mcu7t5v0__fill_2
XPHY_EDGE_ROW_76_Left_198 VDD VSS gf180mcu_fd_sc_mcu7t5v0__endcap
X_2090_ _4146_/Q _3398_/A3 _3723_/B _4140_/Q _2091_/B VDD VDD VSS VSS gf180mcu_fd_sc_mcu7t5v0__aoi22_1
X_2992_ _4020_/Q _3241_/A1 _3013_/B1 _3996_/Q _3988_/Q _3173_/A1 _2998_/A1 VDD VDD
+ VSS VSS gf180mcu_fd_sc_mcu7t5v0__aoi222_1
XFILLER_9_41 VDD VDD VSS VSS gf180mcu_fd_sc_mcu7t5v0__fill_1
X_1943_ _1943_/I _3215_/A1 VDD VDD VSS VSS gf180mcu_fd_sc_mcu7t5v0__clkinv_1
X_3613_ hold215/Z _3669_/A2 _3669_/B1 _3613_/B2 _3614_/A2 VDD VDD VSS VSS gf180mcu_fd_sc_mcu7t5v0__aoi22_1
XFILLER_115_333 VDD VDD VSS VSS gf180mcu_fd_sc_mcu7t5v0__fillcap_4
X_3544_ _4102_/Q _3538_/B _3536_/C _4102_/D VDD VDD VSS VSS gf180mcu_fd_sc_mcu7t5v0__and3_1
X_3475_ _4083_/Q _3475_/A2 _3476_/B2 VDD VDD VSS VSS gf180mcu_fd_sc_mcu7t5v0__xnor2_1
X_2426_ _2459_/A1 _3815_/Q _2453_/B VDD VDD VSS VSS gf180mcu_fd_sc_mcu7t5v0__nor2_1
XFILLER_29_306 VDD VDD VSS VSS gf180mcu_fd_sc_mcu7t5v0__fill_2
X_2357_ _2357_/A1 _2356_/B _2357_/B _2362_/C _3822_/D VDD VDD VSS VSS gf180mcu_fd_sc_mcu7t5v0__aoi211_1
X_2288_ _2280_/Z _2282_/Z _2283_/Z _2288_/A4 _2349_/B VDD VDD VSS VSS gf180mcu_fd_sc_mcu7t5v0__nor4_1
XFILLER_96_294 VDD VDD VSS VSS gf180mcu_fd_sc_mcu7t5v0__fillcap_16
XTAP_TAPCELL_ROW_67_654 VDD VSS gf180mcu_fd_sc_mcu7t5v0__filltie
X_4027_ _4027_/D _4166_/CLK _4027_/Q VDD VDD VSS VSS gf180mcu_fd_sc_mcu7t5v0__dffq_1
XFILLER_44_16 VDD VDD VSS VSS gf180mcu_fd_sc_mcu7t5v0__fillcap_16
XFILLER_71_128 VDD VDD VSS VSS gf180mcu_fd_sc_mcu7t5v0__fillcap_8
XTAP_TAPCELL_ROW_50_554 VDD VSS gf180mcu_fd_sc_mcu7t5v0__filltie
XFILLER_79_217 VDD VDD VSS VSS gf180mcu_fd_sc_mcu7t5v0__fill_2
XFILLER_121_358 VDD VDD VSS VSS gf180mcu_fd_sc_mcu7t5v0__fillcap_16
XFILLER_87_261 VDD VDD VSS VSS gf180mcu_fd_sc_mcu7t5v0__fill_2
XFILLER_28_350 VDD VDD VSS VSS gf180mcu_fd_sc_mcu7t5v0__fillcap_4
XFILLER_70_150 VDD VDD VSS VSS gf180mcu_fd_sc_mcu7t5v0__fillcap_16
Xclkbuf_leaf_15_ext_clk_in clkbuf_leaf_1_ext_clk_in/I clkload5/I VDD VDD VSS VSS gf180mcu_fd_sc_mcu7t5v0__clkbuf_8
XPHY_EDGE_ROW_84_Left_206 VDD VSS gf180mcu_fd_sc_mcu7t5v0__endcap
X_3260_ _3260_/A1 _3274_/A2 _3260_/B _4023_/D VDD VDD VSS VSS gf180mcu_fd_sc_mcu7t5v0__aoi21_1
X_2211_ _2211_/A1 _2211_/A2 _3790_/D VDD VDD VSS VSS gf180mcu_fd_sc_mcu7t5v0__nor2_1
X_3191_ wire94/Z _3206_/A2 wire81/Z _3192_/B VDD VDD VSS VSS gf180mcu_fd_sc_mcu7t5v0__oai21_1
X_2142_ _2142_/A1 _2142_/A2 _3767_/D VDD VDD VSS VSS gf180mcu_fd_sc_mcu7t5v0__nor2_1
X_2073_ _3917_/Q _2926_/B VDD VDD VSS VSS gf180mcu_fd_sc_mcu7t5v0__clkinv_1
XTAP_TAPCELL_ROW_64_635 VDD VSS gf180mcu_fd_sc_mcu7t5v0__filltie
Xload_slew82 _3256_/B _3746_/B VDD VDD VSS VSS gf180mcu_fd_sc_mcu7t5v0__buf_16
XPHY_EDGE_ROW_93_Left_215 VDD VSS gf180mcu_fd_sc_mcu7t5v0__endcap
X_2975_ _4010_/Q _3224_/A1 _3105_/A1 _3954_/Q _2977_/A3 VDD VDD VSS VSS gf180mcu_fd_sc_mcu7t5v0__aoi22_1
X_1926_ _1926_/I _3251_/A1 VDD VDD VSS VSS gf180mcu_fd_sc_mcu7t5v0__clkinv_1
X_3527_ _3536_/A2 _3527_/A2 _3527_/B _3527_/ZN VDD VDD VSS VSS gf180mcu_fd_sc_mcu7t5v0__aoi21_1
XFILLER_103_314 VDD VDD VSS VSS gf180mcu_fd_sc_mcu7t5v0__fillcap_4
X_3458_ _3458_/I _3551_/B1 VDD VDD VSS VSS gf180mcu_fd_sc_mcu7t5v0__clkinv_1
X_3389_ _4079_/Q _4078_/Q _4077_/Q _4076_/Q _3392_/A3 VDD VDD VSS VSS gf180mcu_fd_sc_mcu7t5v0__nor4_1
X_2409_ _2409_/I _3848_/D VDD VDD VSS VSS gf180mcu_fd_sc_mcu7t5v0__clkinv_1
XTAP_TAPCELL_ROW_4_279 VDD VSS gf180mcu_fd_sc_mcu7t5v0__filltie
XFILLER_25_320 VDD VDD VSS VSS gf180mcu_fd_sc_mcu7t5v0__fill_1
XTAP_TAPCELL_ROW_107_894 VDD VSS gf180mcu_fd_sc_mcu7t5v0__filltie
XFILLER_52_183 VDD VDD VSS VSS gf180mcu_fd_sc_mcu7t5v0__fill_1
XFILLER_52_172 VDD VDD VSS VSS gf180mcu_fd_sc_mcu7t5v0__fill_2
XPHY_EDGE_ROW_109_Right_109 VDD VSS gf180mcu_fd_sc_mcu7t5v0__endcap
XFILLER_20_95 VDD VDD VSS VSS gf180mcu_fd_sc_mcu7t5v0__fill_1
XFILLER_106_174 VDD VDD VSS VSS gf180mcu_fd_sc_mcu7t5v0__fill_1
XFILLER_96_55 VDD VDD VSS VSS gf180mcu_fd_sc_mcu7t5v0__fill_2
XTAP_TAPCELL_ROW_86_771 VDD VSS gf180mcu_fd_sc_mcu7t5v0__filltie
XTAP_TAPCELL_ROW_18_359 VDD VSS gf180mcu_fd_sc_mcu7t5v0__filltie
XTAP_TAPCELL_ROW_61_616 VDD VSS gf180mcu_fd_sc_mcu7t5v0__filltie
X_2760_ _2750_/Z _2757_/Z _2760_/B _2760_/C _3894_/D VDD VDD VSS VSS gf180mcu_fd_sc_mcu7t5v0__aoi211_1
X_2691_ _4029_/Q _2847_/A2 _2653_/B _2691_/B _2692_/B VDD VDD VSS VSS gf180mcu_fd_sc_mcu7t5v0__oai31_1
XFILLER_6_31 VDD VDD VSS VSS gf180mcu_fd_sc_mcu7t5v0__fillcap_4
XFILLER_6_75 VDD VDD VSS VSS gf180mcu_fd_sc_mcu7t5v0__fill_1
XFILLER_6_97 VDD VDD VSS VSS gf180mcu_fd_sc_mcu7t5v0__fillcap_8
XFILLER_3_290 VDD VDD VSS VSS gf180mcu_fd_sc_mcu7t5v0__fill_2
X_3312_ hold161/Z _3308_/Z _3312_/B _3313_/I VDD VDD VSS VSS gf180mcu_fd_sc_mcu7t5v0__oai21_1
XFILLER_112_177 VDD VDD VSS VSS gf180mcu_fd_sc_mcu7t5v0__fillcap_16
X_3243_ _3243_/A1 _3243_/A2 _3243_/B _4015_/D VDD VDD VSS VSS gf180mcu_fd_sc_mcu7t5v0__aoi21_1
XFILLER_98_389 VDD VDD VSS VSS gf180mcu_fd_sc_mcu7t5v0__fill_1
XFILLER_100_317 VDD VDD VSS VSS gf180mcu_fd_sc_mcu7t5v0__fill_1
XFILLER_39_412 VDD VDD VSS VSS gf180mcu_fd_sc_mcu7t5v0__fillcap_8
X_3174_ wire94/I wire44/Z wire81/I _3175_/B VDD VDD VSS VSS gf180mcu_fd_sc_mcu7t5v0__oai21_1
XFILLER_66_231 VDD VDD VSS VSS gf180mcu_fd_sc_mcu7t5v0__fillcap_4
XFILLER_81_201 VDD VDD VSS VSS gf180mcu_fd_sc_mcu7t5v0__fillcap_8
XFILLER_81_212 VDD VDD VSS VSS gf180mcu_fd_sc_mcu7t5v0__fillcap_4
X_2125_ _4043_/Q _2155_/A2 _2127_/A1 VDD VDD VSS VSS gf180mcu_fd_sc_mcu7t5v0__nor2_1
X_2056_ _3904_/Q _2687_/A2 VDD VDD VSS VSS gf180mcu_fd_sc_mcu7t5v0__clkinv_1
XFILLER_22_323 VDD VDD VSS VSS gf180mcu_fd_sc_mcu7t5v0__fill_2
XFILLER_22_312 VDD VDD VSS VSS gf180mcu_fd_sc_mcu7t5v0__fill_2
XTAP_TAPCELL_ROW_104_875 VDD VSS gf180mcu_fd_sc_mcu7t5v0__filltie
X_2958_ _3720_/A2 _2958_/A2 _3042_/B1 VDD VDD VSS VSS gf180mcu_fd_sc_mcu7t5v0__nor2_1
X_1909_ _4036_/Q _3287_/A1 VDD VDD VSS VSS gf180mcu_fd_sc_mcu7t5v0__clkinv_1
X_2889_ _2897_/B2 _2896_/B _2891_/A1 VDD VDD VSS VSS gf180mcu_fd_sc_mcu7t5v0__nand2_1
XTAP_TAPCELL_ROW_9_305 VDD VSS gf180mcu_fd_sc_mcu7t5v0__filltie
XFILLER_103_155 VDD VDD VSS VSS gf180mcu_fd_sc_mcu7t5v0__fillcap_4
XFILLER_66_14 VDD VDD VSS VSS gf180mcu_fd_sc_mcu7t5v0__fillcap_8
XFILLER_106_87 VDD VDD VSS VSS gf180mcu_fd_sc_mcu7t5v0__fill_1
XFILLER_57_264 VDD VDD VSS VSS gf180mcu_fd_sc_mcu7t5v0__fill_1
XFILLER_17_139 VDD VDD VSS VSS gf180mcu_fd_sc_mcu7t5v0__fill_1
XTAP_TAPCELL_ROW_83_752 VDD VSS gf180mcu_fd_sc_mcu7t5v0__filltie
XFILLER_82_57 VDD VDD VSS VSS gf180mcu_fd_sc_mcu7t5v0__fillcap_16
XFILLER_9_327 VDD VDD VSS VSS gf180mcu_fd_sc_mcu7t5v0__fillcap_8
XFILLER_31_72 VDD VDD VSS VSS gf180mcu_fd_sc_mcu7t5v0__fillcap_8
XFILLER_63_212 VDD VDD VSS VSS gf180mcu_fd_sc_mcu7t5v0__fill_1
Xclkbuf_leaf_5_ext_clk_in clkload0/I _4034_/CLK VDD VDD VSS VSS gf180mcu_fd_sc_mcu7t5v0__clkbuf_8
XFILLER_63_256 VDD VDD VSS VSS gf180mcu_fd_sc_mcu7t5v0__fill_2
X_3930_ _3930_/D _4169_/CLK _3930_/Q VDD VDD VSS VSS gf180mcu_fd_sc_mcu7t5v0__dffq_1
X_3861_ _3861_/D _4021_/CLK _3861_/Q VDD VDD VSS VSS gf180mcu_fd_sc_mcu7t5v0__dffq_1
X_2812_ _2929_/A1 _2811_/Z _3901_/D VDD VDD VSS VSS gf180mcu_fd_sc_mcu7t5v0__nor2_1
X_3792_ _3792_/D clkload4/I _3792_/Q VDD VDD VSS VSS gf180mcu_fd_sc_mcu7t5v0__dffq_1
XTAP_TAPCELL_ROW_101_856 VDD VSS gf180mcu_fd_sc_mcu7t5v0__filltie
X_2743_ _2743_/A1 _2743_/A2 _2744_/A2 VDD VDD VSS VSS gf180mcu_fd_sc_mcu7t5v0__nand2_1
X_2674_ _3260_/A1 _3901_/Q _2679_/A3 VDD VDD VSS VSS gf180mcu_fd_sc_mcu7t5v0__nor2_1
XTAP_TAPCELL_ROW_97_833 VDD VSS gf180mcu_fd_sc_mcu7t5v0__filltie
X_3226_ _2628_/C _3240_/A2 _3226_/B _4007_/D VDD VDD VSS VSS gf180mcu_fd_sc_mcu7t5v0__aoi21_1
X_3157_ wire94/I _3170_/A2 wire81/I _3158_/B VDD VDD VSS VSS gf180mcu_fd_sc_mcu7t5v0__oai21_1
X_2108_ _4123_/Q _4122_/Q _3675_/A2 VDD VDD VSS VSS gf180mcu_fd_sc_mcu7t5v0__nor2_1
X_3088_ _3088_/A1 _3241_/A2 _3090_/A2 VDD VDD VSS VSS gf180mcu_fd_sc_mcu7t5v0__nand2_1
X_2039_ _3825_/Q _2367_/A1 VDD VDD VSS VSS gf180mcu_fd_sc_mcu7t5v0__clkinv_1
XTAP_TAPCELL_ROW_37_476 VDD VSS gf180mcu_fd_sc_mcu7t5v0__filltie
XTAP_TAPCELL_ROW_80_733 VDD VSS gf180mcu_fd_sc_mcu7t5v0__filltie
XFILLER_89_131 VDD VDD VSS VSS gf180mcu_fd_sc_mcu7t5v0__fill_1
XFILLER_77_57 VDD VDD VSS VSS gf180mcu_fd_sc_mcu7t5v0__fillcap_8
XTAP_TAPCELL_ROW_28_421 VDD VSS gf180mcu_fd_sc_mcu7t5v0__filltie
XFILLER_33_418 VDD VDD VSS VSS gf180mcu_fd_sc_mcu7t5v0__fill_2
XFILLER_45_278 VDD VDD VSS VSS gf180mcu_fd_sc_mcu7t5v0__fill_2
XTAP_TAPCELL_ROW_11_321 VDD VSS gf180mcu_fd_sc_mcu7t5v0__filltie
XFILLER_5_352 VDD VDD VSS VSS gf180mcu_fd_sc_mcu7t5v0__fillcap_64
XFILLER_47_6 VDD VDD VSS VSS gf180mcu_fd_sc_mcu7t5v0__fill_2
X_2390_ _3873_/Q _2383_/I _2400_/B1 _3839_/Q _2391_/I VDD VDD VSS VSS gf180mcu_fd_sc_mcu7t5v0__aoi22_1
XFILLER_3_76 VDD VDD VSS VSS gf180mcu_fd_sc_mcu7t5v0__fill_2
X_4060_ _4060_/D _4104_/CLK _4060_/Q VDD VDD VSS VSS gf180mcu_fd_sc_mcu7t5v0__dffq_1
XFILLER_36_201 VDD VDD VSS VSS gf180mcu_fd_sc_mcu7t5v0__fill_2
X_3011_ _4038_/Q _3027_/C1 _3036_/A2 _4022_/Q _4014_/Q _3224_/A1 _3017_/A1 VDD VDD
+ VSS VSS gf180mcu_fd_sc_mcu7t5v0__aoi222_1
XTAP_TAPCELL_ROW_94_814 VDD VSS gf180mcu_fd_sc_mcu7t5v0__filltie
XFILLER_91_362 VDD VDD VSS VSS gf180mcu_fd_sc_mcu7t5v0__fill_1
XTAP_TAPCELL_ROW_34_457 VDD VSS gf180mcu_fd_sc_mcu7t5v0__filltie
X_3913_ _3913_/D _4170_/CLK _3913_/Q VDD VDD VSS VSS gf180mcu_fd_sc_mcu7t5v0__dffq_1
X_3844_ _3844_/D clkload3/I _3844_/Q VDD VDD VSS VSS gf180mcu_fd_sc_mcu7t5v0__dffq_1
X_3775_ _3775_/D _4058_/CLK _3775_/Q VDD VDD VSS VSS gf180mcu_fd_sc_mcu7t5v0__dffq_1
X_2726_ _3948_/Q _3890_/Q _2726_/Z VDD VDD VSS VSS gf180mcu_fd_sc_mcu7t5v0__xor2_1
X_2657_ _2690_/B _2686_/A1 _2658_/A3 VDD VDD VSS VSS gf180mcu_fd_sc_mcu7t5v0__nor2_1
X_2588_ _3177_/A1 _3894_/Q _3893_/Q _3175_/A1 _2592_/A2 VDD VDD VSS VSS gf180mcu_fd_sc_mcu7t5v0__aoi22_1
XFILLER_86_123 VDD VDD VSS VSS gf180mcu_fd_sc_mcu7t5v0__fill_2
XFILLER_47_38 VDD VDD VSS VSS gf180mcu_fd_sc_mcu7t5v0__fill_1
X_3209_ _3209_/A1 _3217_/A2 _3209_/B _3999_/D VDD VDD VSS VSS gf180mcu_fd_sc_mcu7t5v0__aoi21_1
XFILLER_27_212 VDD VDD VSS VSS gf180mcu_fd_sc_mcu7t5v0__fillcap_8
XFILLER_103_22 VDD VDD VSS VSS gf180mcu_fd_sc_mcu7t5v0__fill_2
XTAP_TAPCELL_ROW_25_402 VDD VSS gf180mcu_fd_sc_mcu7t5v0__filltie
XTAP_TAPCELL_ROW_120_973 VDD VSS gf180mcu_fd_sc_mcu7t5v0__filltie
XFILLER_88_34 VDD VDD VSS VSS gf180mcu_fd_sc_mcu7t5v0__fill_1
XFILLER_5_2 VDD VDD VSS VSS gf180mcu_fd_sc_mcu7t5v0__fillcap_4
XFILLER_88_67 VDD VDD VSS VSS gf180mcu_fd_sc_mcu7t5v0__fillcap_4
Xhold190 _3867_/Q hold190/Z VDD VDD VSS VSS gf180mcu_fd_sc_mcu7t5v0__dlyc_1
XTAP_TAPCELL_ROW_48_538 VDD VSS gf180mcu_fd_sc_mcu7t5v0__filltie
XPHY_EDGE_ROW_16_Right_16 VDD VSS gf180mcu_fd_sc_mcu7t5v0__endcap
X_1890_ _1890_/I _3574_/A1 VDD VDD VSS VSS gf180mcu_fd_sc_mcu7t5v0__clkinv_1
XTAP_TAPCELL_ROW_31_438 VDD VSS gf180mcu_fd_sc_mcu7t5v0__filltie
Xclkbuf_1_1__f__1468_ clkbuf_0__1468_/Z _3455_/A3 VDD VDD VSS VSS gf180mcu_fd_sc_mcu7t5v0__clkbuf_16
XPHY_EDGE_ROW_25_Right_25 VDD VSS gf180mcu_fd_sc_mcu7t5v0__endcap
X_3560_ _4107_/Q _3569_/A2 _3561_/C VDD VDD VSS VSS gf180mcu_fd_sc_mcu7t5v0__nor2_1
X_2511_ _3871_/Q _2546_/B _2515_/B2 VDD VDD VSS VSS gf180mcu_fd_sc_mcu7t5v0__nand2_1
X_3491_ _4087_/Q _3486_/Z _3492_/I VDD VDD VSS VSS gf180mcu_fd_sc_mcu7t5v0__and2_1
X_2442_ _3256_/B _2442_/A2 _2442_/A3 _3858_/D VDD VDD VSS VSS gf180mcu_fd_sc_mcu7t5v0__nand3_1
X_2373_ _3831_/Q _3832_/Q _2373_/S _3832_/D VDD VDD VSS VSS gf180mcu_fd_sc_mcu7t5v0__mux2_2
X_4112_ _4112_/D clkload5/I _4112_/Q VDD VDD VSS VSS gf180mcu_fd_sc_mcu7t5v0__dffq_1
X_4043_ _4043_/D _4164_/CLK _4043_/Q VDD VDD VSS VSS gf180mcu_fd_sc_mcu7t5v0__dffq_1
XPHY_EDGE_ROW_34_Right_34 VDD VSS gf180mcu_fd_sc_mcu7t5v0__endcap
X_3827_ _3827_/D clkload8/I _3827_/Q VDD VDD VSS VSS gf180mcu_fd_sc_mcu7t5v0__dffq_1
XPHY_EDGE_ROW_43_Right_43 VDD VSS gf180mcu_fd_sc_mcu7t5v0__endcap
X_3758_ _3758_/D _4058_/CLK _3758_/Q VDD VDD VSS VSS gf180mcu_fd_sc_mcu7t5v0__dffq_1
XPHY_EDGE_ROW_104_Left_226 VDD VSS gf180mcu_fd_sc_mcu7t5v0__endcap
XFILLER_118_375 VDD VDD VSS VSS gf180mcu_fd_sc_mcu7t5v0__fill_1
X_2709_ _3945_/Q _3887_/Q _2709_/Z VDD VDD VSS VSS gf180mcu_fd_sc_mcu7t5v0__xor2_1
X_3689_ wire90/Z _3692_/A2 _3691_/A1 VDD VDD VSS VSS gf180mcu_fd_sc_mcu7t5v0__nor2_1
XFILLER_59_101 VDD VDD VSS VSS gf180mcu_fd_sc_mcu7t5v0__fillcap_16
XFILLER_101_220 VDD VDD VSS VSS gf180mcu_fd_sc_mcu7t5v0__fill_2
XPHY_EDGE_ROW_113_Left_235 VDD VSS gf180mcu_fd_sc_mcu7t5v0__endcap
XPHY_EDGE_ROW_52_Right_52 VDD VSS gf180mcu_fd_sc_mcu7t5v0__endcap
XFILLER_101_242 VDD VDD VSS VSS gf180mcu_fd_sc_mcu7t5v0__fill_2
XFILLER_74_115 VDD VDD VSS VSS gf180mcu_fd_sc_mcu7t5v0__fill_2
XFILLER_101_286 VDD VDD VSS VSS gf180mcu_fd_sc_mcu7t5v0__fill_2
XPHY_EDGE_ROW_61_Right_61 VDD VSS gf180mcu_fd_sc_mcu7t5v0__endcap
XPHY_EDGE_ROW_70_Right_70 VDD VSS gf180mcu_fd_sc_mcu7t5v0__endcap
XFILLER_46_384 VDD VDD VSS VSS gf180mcu_fd_sc_mcu7t5v0__fill_1
XFILLER_80_107 VDD VDD VSS VSS gf180mcu_fd_sc_mcu7t5v0__fillcap_8
XFILLER_73_192 VDD VDD VSS VSS gf180mcu_fd_sc_mcu7t5v0__fill_2
XFILLER_21_218 VDD VDD VSS VSS gf180mcu_fd_sc_mcu7t5v0__fillcap_4
X_2991_ _4004_/Q _3207_/A1 _2997_/A1 VDD VDD VSS VSS gf180mcu_fd_sc_mcu7t5v0__nand2_1
X_1942_ _1942_/I _3217_/A1 VDD VDD VSS VSS gf180mcu_fd_sc_mcu7t5v0__clkinv_1
X_3612_ _3612_/A1 _3612_/A2 _3613_/B2 VDD VDD VSS VSS gf180mcu_fd_sc_mcu7t5v0__nand2_1
X_3543_ _4101_/Q _3538_/B _3545_/A3 _4101_/D VDD VDD VSS VSS gf180mcu_fd_sc_mcu7t5v0__and3_1
XFILLER_115_345 VDD VDD VSS VSS gf180mcu_fd_sc_mcu7t5v0__fillcap_4
X_3474_ _4083_/Q _4082_/Q _4081_/Q _4080_/Q _3474_/Z VDD VDD VSS VSS gf180mcu_fd_sc_mcu7t5v0__and4_1
X_2425_ _3884_/Q _3883_/Q _2428_/B VDD VDD VSS VSS gf180mcu_fd_sc_mcu7t5v0__nor2_1
X_2356_ _2360_/A3 _2356_/A2 _2356_/B _2357_/B VDD VDD VSS VSS gf180mcu_fd_sc_mcu7t5v0__aoi21_1
XFILLER_56_104 VDD VDD VSS VSS gf180mcu_fd_sc_mcu7t5v0__fill_1
XFILLER_96_251 VDD VDD VSS VSS gf180mcu_fd_sc_mcu7t5v0__fill_2
X_2287_ _2273_/Z _2287_/A2 _2288_/A4 VDD VDD VSS VSS gf180mcu_fd_sc_mcu7t5v0__nand2_1
XTAP_TAPCELL_ROW_67_655 VDD VSS gf180mcu_fd_sc_mcu7t5v0__filltie
X_4026_ _4026_/D _4155_/CLK _4026_/Q VDD VDD VSS VSS gf180mcu_fd_sc_mcu7t5v0__dffq_1
XFILLER_64_170 VDD VDD VSS VSS gf180mcu_fd_sc_mcu7t5v0__fillcap_4
XTAP_TAPCELL_ROW_50_555 VDD VSS gf180mcu_fd_sc_mcu7t5v0__filltie
XFILLER_60_49 VDD VDD VSS VSS gf180mcu_fd_sc_mcu7t5v0__fill_1
XFILLER_118_183 VDD VDD VSS VSS gf180mcu_fd_sc_mcu7t5v0__fill_1
XFILLER_106_334 VDD VDD VSS VSS gf180mcu_fd_sc_mcu7t5v0__fillcap_16
XFILLER_79_229 VDD VDD VSS VSS gf180mcu_fd_sc_mcu7t5v0__fillcap_4
XFILLER_106_378 VDD VDD VSS VSS gf180mcu_fd_sc_mcu7t5v0__fillcap_4
XTAP_TAPCELL_ROW_58_600 VDD VSS gf180mcu_fd_sc_mcu7t5v0__filltie
XFILLER_28_384 VDD VDD VSS VSS gf180mcu_fd_sc_mcu7t5v0__fill_1
XFILLER_62_107 VDD VDD VSS VSS gf180mcu_fd_sc_mcu7t5v0__fill_2
XFILLER_70_140 VDD VDD VSS VSS gf180mcu_fd_sc_mcu7t5v0__fill_2
XTAP_TAPCELL_ROW_41_500 VDD VSS gf180mcu_fd_sc_mcu7t5v0__filltie
XFILLER_109_150 VDD VDD VSS VSS gf180mcu_fd_sc_mcu7t5v0__fill_2
XFILLER_50_93 VDD VDD VSS VSS gf180mcu_fd_sc_mcu7t5v0__fill_2
X_2210_ hold206/Z _2111_/Z _3746_/B _2211_/A2 VDD VDD VSS VSS gf180mcu_fd_sc_mcu7t5v0__oai21_1
X_3190_ _3190_/A1 _3275_/A2 _3206_/A2 VDD VDD VSS VSS gf180mcu_fd_sc_mcu7t5v0__nand2_1
XFILLER_38_137 VDD VDD VSS VSS gf180mcu_fd_sc_mcu7t5v0__fill_1
X_2141_ _3767_/Q _2243_/A2 _3746_/B _2142_/A2 VDD VDD VSS VSS gf180mcu_fd_sc_mcu7t5v0__oai21_1
X_2072_ _3885_/Q _2573_/B1 VDD VDD VSS VSS gf180mcu_fd_sc_mcu7t5v0__clkinv_1
Xload_slew83 _3256_/B wire81/I VDD VDD VSS VSS gf180mcu_fd_sc_mcu7t5v0__buf_12
XFILLER_46_181 VDD VDD VSS VSS gf180mcu_fd_sc_mcu7t5v0__fill_2
XTAP_TAPCELL_ROW_64_636 VDD VSS gf180mcu_fd_sc_mcu7t5v0__filltie
XFILLER_34_365 VDD VDD VSS VSS gf180mcu_fd_sc_mcu7t5v0__fillcap_4
XFILLER_34_387 VDD VDD VSS VSS gf180mcu_fd_sc_mcu7t5v0__fillcap_32
X_2974_ _4002_/Q _3207_/A1 _3057_/A1 _3935_/Q _2974_/C _2977_/A2 VDD VDD VSS VSS gf180mcu_fd_sc_mcu7t5v0__aoi221_1
X_1925_ _4020_/Q _3253_/A1 VDD VDD VSS VSS gf180mcu_fd_sc_mcu7t5v0__clkinv_1
Xtop_level ext_clk_in_pd_control VDD VDD VSS VSS gf180mcu_fd_sc_mcu7t5v0__tiel
X_3526_ _4095_/Q _3526_/A2 _3527_/A2 VDD VDD VSS VSS gf180mcu_fd_sc_mcu7t5v0__nand2_1
X_3457_ _4142_/Q _4104_/Q _3458_/I VDD VDD VSS VSS gf180mcu_fd_sc_mcu7t5v0__xor2_1
X_3388_ _4075_/Q _4074_/Q _4073_/Q _3392_/A2 VDD VDD VSS VSS gf180mcu_fd_sc_mcu7t5v0__nor3_1
X_2408_ _3848_/Q wire51/Z _2404_/B _3808_/Q _2409_/I VDD VDD VSS VSS gf180mcu_fd_sc_mcu7t5v0__aoi22_1
XFILLER_69_262 VDD VDD VSS VSS gf180mcu_fd_sc_mcu7t5v0__fillcap_8
XFILLER_111_381 VDD VDD VSS VSS gf180mcu_fd_sc_mcu7t5v0__fill_1
X_2339_ _2339_/A1 _2339_/A2 _2349_/B _2342_/A2 VDD VDD VSS VSS gf180mcu_fd_sc_mcu7t5v0__aoi21_1
XFILLER_29_104 VDD VDD VSS VSS gf180mcu_fd_sc_mcu7t5v0__fillcap_8
XFILLER_84_221 VDD VDD VSS VSS gf180mcu_fd_sc_mcu7t5v0__fill_1
XPHY_EDGE_ROW_2_Right_2 VDD VSS gf180mcu_fd_sc_mcu7t5v0__endcap
X_4009_ _4009_/D _4017_/CLK _4009_/Q VDD VDD VSS VSS gf180mcu_fd_sc_mcu7t5v0__dffq_1
XFILLER_44_107 VDD VDD VSS VSS gf180mcu_fd_sc_mcu7t5v0__fillcap_64
XTAP_TAPCELL_ROW_107_895 VDD VSS gf180mcu_fd_sc_mcu7t5v0__filltie
XFILLER_111_66 VDD VDD VSS VSS gf180mcu_fd_sc_mcu7t5v0__fillcap_4
XFILLER_111_88 VDD VDD VSS VSS gf180mcu_fd_sc_mcu7t5v0__fillcap_8
XFILLER_40_368 VDD VDD VSS VSS gf180mcu_fd_sc_mcu7t5v0__fill_1
XFILLER_71_48 VDD VDD VSS VSS gf180mcu_fd_sc_mcu7t5v0__fillcap_16
XFILLER_4_247 VDD VDD VSS VSS gf180mcu_fd_sc_mcu7t5v0__fill_1
XFILLER_4_258 VDD VDD VSS VSS gf180mcu_fd_sc_mcu7t5v0__fill_1
XFILLER_121_101 VDD VDD VSS VSS gf180mcu_fd_sc_mcu7t5v0__fill_1
XFILLER_20_85 VDD VDD VSS VSS gf180mcu_fd_sc_mcu7t5v0__fillcap_8
XFILLER_96_45 VDD VDD VSS VSS gf180mcu_fd_sc_mcu7t5v0__fill_2
XFILLER_102_381 VDD VDD VSS VSS gf180mcu_fd_sc_mcu7t5v0__fillcap_4
XFILLER_29_72 VDD VDD VSS VSS gf180mcu_fd_sc_mcu7t5v0__fillcap_32
XFILLER_35_118 VDD VDD VSS VSS gf180mcu_fd_sc_mcu7t5v0__fillcap_16
XFILLER_75_276 VDD VDD VSS VSS gf180mcu_fd_sc_mcu7t5v0__fillcap_4
XFILLER_28_192 VDD VDD VSS VSS gf180mcu_fd_sc_mcu7t5v0__fill_1
XTAP_TAPCELL_ROW_61_617 VDD VSS gf180mcu_fd_sc_mcu7t5v0__filltie
XFILLER_16_387 VDD VDD VSS VSS gf180mcu_fd_sc_mcu7t5v0__fillcap_32
XFILLER_61_92 VDD VDD VSS VSS gf180mcu_fd_sc_mcu7t5v0__fill_1
X_2690_ _4028_/Q _2845_/A2 _2690_/B _2692_/A2 VDD VDD VSS VSS gf180mcu_fd_sc_mcu7t5v0__aoi21_1
X_3311_ _3363_/B _3310_/Z _3312_/B VDD VDD VSS VSS gf180mcu_fd_sc_mcu7t5v0__nor2_1
XFILLER_112_101 VDD VDD VSS VSS gf180mcu_fd_sc_mcu7t5v0__fillcap_4
X_3242_ wire94/I _3243_/A2 wire81/I _3243_/B VDD VDD VSS VSS gf180mcu_fd_sc_mcu7t5v0__oai21_1
XFILLER_98_379 VDD VDD VSS VSS gf180mcu_fd_sc_mcu7t5v0__fillcap_4
XFILLER_20_2 VDD VDD VSS VSS gf180mcu_fd_sc_mcu7t5v0__fill_2
X_3173_ _3173_/A1 _3241_/A2 wire44/I VDD VDD VSS VSS gf180mcu_fd_sc_mcu7t5v0__nand2_1
X_2124_ _2124_/A1 _2124_/A2 hold193/I VDD VDD VSS VSS gf180mcu_fd_sc_mcu7t5v0__nor2_1
XFILLER_26_107 VDD VDD VSS VSS gf180mcu_fd_sc_mcu7t5v0__fillcap_16
X_2055_ _3905_/Q _2844_/A2 VDD VDD VSS VSS gf180mcu_fd_sc_mcu7t5v0__clkinv_1
XFILLER_81_279 VDD VDD VSS VSS gf180mcu_fd_sc_mcu7t5v0__fill_1
XFILLER_22_302 VDD VDD VSS VSS gf180mcu_fd_sc_mcu7t5v0__fillcap_4
XTAP_TAPCELL_ROW_104_876 VDD VSS gf180mcu_fd_sc_mcu7t5v0__filltie
XFILLER_22_379 VDD VDD VSS VSS gf180mcu_fd_sc_mcu7t5v0__fillcap_4
X_2957_ _2957_/A1 _2947_/Z _3258_/A1 VDD VDD VSS VSS gf180mcu_fd_sc_mcu7t5v0__nor2_1
X_2888_ _3970_/Q _3912_/Q _2896_/B VDD VDD VSS VSS gf180mcu_fd_sc_mcu7t5v0__nand2_1
X_1908_ _1908_/I _3289_/A1 VDD VDD VSS VSS gf180mcu_fd_sc_mcu7t5v0__clkinv_1
XTAP_TAPCELL_ROW_9_306 VDD VSS gf180mcu_fd_sc_mcu7t5v0__filltie
XFILLER_1_228 VDD VDD VSS VSS gf180mcu_fd_sc_mcu7t5v0__fillcap_8
X_3509_ _4091_/Q _3513_/A2 _3536_/A2 _3509_/B2 _3510_/B VDD VDD VSS VSS gf180mcu_fd_sc_mcu7t5v0__aoi22_1
XFILLER_89_324 VDD VDD VSS VSS gf180mcu_fd_sc_mcu7t5v0__fill_1
XFILLER_66_26 VDD VDD VSS VSS gf180mcu_fd_sc_mcu7t5v0__fillcap_8
XFILLER_66_37 VDD VDD VSS VSS gf180mcu_fd_sc_mcu7t5v0__fill_1
XTAP_TAPCELL_ROW_0_250 VDD VSS gf180mcu_fd_sc_mcu7t5v0__filltie
XFILLER_60_419 VDD VDD VSS VSS gf180mcu_fd_sc_mcu7t5v0__fillcap_4
XTAP_TAPCELL_ROW_83_753 VDD VSS gf180mcu_fd_sc_mcu7t5v0__filltie
XFILLER_15_63 VDD VDD VSS VSS gf180mcu_fd_sc_mcu7t5v0__fillcap_4
XFILLER_31_84 VDD VDD VSS VSS gf180mcu_fd_sc_mcu7t5v0__fill_1
XFILLER_63_279 VDD VDD VSS VSS gf180mcu_fd_sc_mcu7t5v0__fill_1
X_3860_ _3860_/D _4021_/CLK _3860_/Q VDD VDD VSS VSS gf180mcu_fd_sc_mcu7t5v0__dffq_1
X_2811_ wire31/Z _2810_/I _2811_/Z VDD VDD VSS VSS gf180mcu_fd_sc_mcu7t5v0__xor2_1
X_3791_ _3791_/D clkload4/I _3791_/Q VDD VDD VSS VSS gf180mcu_fd_sc_mcu7t5v0__dffq_1
XTAP_TAPCELL_ROW_101_857 VDD VSS gf180mcu_fd_sc_mcu7t5v0__filltie
X_2742_ _2748_/A2 _2741_/Z _2744_/A1 VDD VDD VSS VSS gf180mcu_fd_sc_mcu7t5v0__nand2_1
X_2673_ _4036_/Q _2910_/A2 _2696_/A3 VDD VDD VSS VSS gf180mcu_fd_sc_mcu7t5v0__nand2_1
XPHY_EDGE_ROW_99_Right_99 VDD VSS gf180mcu_fd_sc_mcu7t5v0__endcap
X_3225_ wire94/I _3240_/A2 wire81/I _3226_/B VDD VDD VSS VSS gf180mcu_fd_sc_mcu7t5v0__oai21_1
XTAP_TAPCELL_ROW_97_834 VDD VSS gf180mcu_fd_sc_mcu7t5v0__filltie
XFILLER_98_187 VDD VDD VSS VSS gf180mcu_fd_sc_mcu7t5v0__fill_1
XFILLER_39_232 VDD VDD VSS VSS gf180mcu_fd_sc_mcu7t5v0__fill_2
X_3156_ _3156_/A1 _3241_/A2 _3172_/A2 VDD VDD VSS VSS gf180mcu_fd_sc_mcu7t5v0__nand2_1
XFILLER_39_298 VDD VDD VSS VSS gf180mcu_fd_sc_mcu7t5v0__fillcap_4
X_2107_ wire79/Z _2940_/A3 _3674_/B VDD VDD VSS VSS gf180mcu_fd_sc_mcu7t5v0__nand2_1
X_3087_ _3087_/A1 _3087_/A2 _3087_/B _3942_/D VDD VDD VSS VSS gf180mcu_fd_sc_mcu7t5v0__aoi21_1
X_2038_ _4157_/Q _3256_/B VDD VDD VSS VSS gf180mcu_fd_sc_mcu7t5v0__inv_4
XTAP_TAPCELL_ROW_37_477 VDD VSS gf180mcu_fd_sc_mcu7t5v0__filltie
XTAP_TAPCELL_ROW_80_734 VDD VSS gf180mcu_fd_sc_mcu7t5v0__filltie
X_3989_ _3989_/D clkload2/I _3989_/Q VDD VDD VSS VSS gf180mcu_fd_sc_mcu7t5v0__dffq_1
XFILLER_108_204 VDD VDD VSS VSS gf180mcu_fd_sc_mcu7t5v0__fill_1
XFILLER_117_87 VDD VDD VSS VSS gf180mcu_fd_sc_mcu7t5v0__fill_1
XFILLER_89_154 VDD VDD VSS VSS gf180mcu_fd_sc_mcu7t5v0__fill_2
XFILLER_77_69 VDD VDD VSS VSS gf180mcu_fd_sc_mcu7t5v0__fill_1
XTAP_TAPCELL_ROW_28_422 VDD VSS gf180mcu_fd_sc_mcu7t5v0__filltie
XFILLER_45_224 VDD VDD VSS VSS gf180mcu_fd_sc_mcu7t5v0__fill_1
XFILLER_93_57 VDD VDD VSS VSS gf180mcu_fd_sc_mcu7t5v0__fill_2
XFILLER_42_61 VDD VDD VSS VSS gf180mcu_fd_sc_mcu7t5v0__fill_2
X_3010_ _2345_/C _3010_/A2 _3923_/D VDD VDD VSS VSS gf180mcu_fd_sc_mcu7t5v0__nor2_1
XTAP_TAPCELL_ROW_94_815 VDD VSS gf180mcu_fd_sc_mcu7t5v0__filltie
XFILLER_36_257 VDD VDD VSS VSS gf180mcu_fd_sc_mcu7t5v0__fill_1
XFILLER_24_419 VDD VDD VSS VSS gf180mcu_fd_sc_mcu7t5v0__fillcap_4
X_3912_ _3912_/D _4034_/CLK _3912_/Q VDD VDD VSS VSS gf180mcu_fd_sc_mcu7t5v0__dffq_1
XTAP_TAPCELL_ROW_34_458 VDD VSS gf180mcu_fd_sc_mcu7t5v0__filltie
X_3843_ _3843_/D clkload3/I _3843_/Q VDD VDD VSS VSS gf180mcu_fd_sc_mcu7t5v0__dffq_1
X_3774_ _3774_/D _4058_/CLK _3774_/Q VDD VDD VSS VSS gf180mcu_fd_sc_mcu7t5v0__dffq_1
X_2725_ _3948_/Q _3890_/Q _2735_/A1 VDD VDD VSS VSS gf180mcu_fd_sc_mcu7t5v0__nor2_1
X_2656_ _3266_/A1 _3904_/Q _2656_/B _2686_/A1 VDD VDD VSS VSS gf180mcu_fd_sc_mcu7t5v0__oai21_1
XFILLER_105_207 VDD VDD VSS VSS gf180mcu_fd_sc_mcu7t5v0__fill_2
X_2587_ _3183_/A1 _3897_/Q _3896_/Q _3181_/A1 _2592_/C VDD VDD VSS VSS gf180mcu_fd_sc_mcu7t5v0__aoi22_1
XFILLER_86_102 VDD VDD VSS VSS gf180mcu_fd_sc_mcu7t5v0__fill_2
X_3208_ wire94/Z _3217_/A2 wire81/Z _3209_/B VDD VDD VSS VSS gf180mcu_fd_sc_mcu7t5v0__oai21_1
XFILLER_27_224 VDD VDD VSS VSS gf180mcu_fd_sc_mcu7t5v0__fill_2
X_3139_ _3139_/A1 _3275_/A2 _3155_/A2 VDD VDD VSS VSS gf180mcu_fd_sc_mcu7t5v0__nand2_1
XTAP_TAPCELL_ROW_25_403 VDD VSS gf180mcu_fd_sc_mcu7t5v0__filltie
XFILLER_35_290 VDD VDD VSS VSS gf180mcu_fd_sc_mcu7t5v0__fill_2
XTAP_TAPCELL_ROW_120_974 VDD VSS gf180mcu_fd_sc_mcu7t5v0__filltie
Xhold180 _4148_/Q hold180/Z VDD VDD VSS VSS gf180mcu_fd_sc_mcu7t5v0__dlyc_1
XFILLER_88_57 VDD VDD VSS VSS gf180mcu_fd_sc_mcu7t5v0__fillcap_4
Xhold191 _3785_/Q hold191/Z VDD VDD VSS VSS gf180mcu_fd_sc_mcu7t5v0__dlyc_1
XFILLER_77_146 VDD VDD VSS VSS gf180mcu_fd_sc_mcu7t5v0__fill_1
XFILLER_37_50 VDD VDD VSS VSS gf180mcu_fd_sc_mcu7t5v0__fill_2
XTAP_TAPCELL_ROW_48_539 VDD VSS gf180mcu_fd_sc_mcu7t5v0__filltie
XFILLER_37_72 VDD VDD VSS VSS gf180mcu_fd_sc_mcu7t5v0__fillcap_64
XFILLER_73_363 VDD VDD VSS VSS gf180mcu_fd_sc_mcu7t5v0__fill_1
Xclkbuf_1_1__f__1536_ clkbuf_0__1536_/Z _3547_/A2 VDD VDD VSS VSS gf180mcu_fd_sc_mcu7t5v0__clkbuf_16
XTAP_TAPCELL_ROW_31_439 VDD VSS gf180mcu_fd_sc_mcu7t5v0__filltie
XFILLER_41_282 VDD VDD VSS VSS gf180mcu_fd_sc_mcu7t5v0__fillcap_4
X_2510_ _2549_/A2 _2510_/A2 _2510_/B _2546_/B VDD VDD VSS VSS gf180mcu_fd_sc_mcu7t5v0__oai21_1
X_3490_ _3490_/A1 _3490_/A2 _4086_/D VDD VDD VSS VSS gf180mcu_fd_sc_mcu7t5v0__nor2_1
X_2441_ _3810_/Q _2430_/Z _2442_/A3 VDD VDD VSS VSS gf180mcu_fd_sc_mcu7t5v0__nand2_1
X_2372_ _3830_/Q _3831_/Q _2372_/S _3831_/D VDD VDD VSS VSS gf180mcu_fd_sc_mcu7t5v0__mux2_2
X_4111_ _4111_/D clkload5/I _4111_/Q VDD VDD VSS VSS gf180mcu_fd_sc_mcu7t5v0__dffq_1
XFILLER_78_90 VDD VDD VSS VSS gf180mcu_fd_sc_mcu7t5v0__fill_2
X_4042_ _4042_/D _4052_/CLK _4042_/Q VDD VDD VSS VSS gf180mcu_fd_sc_mcu7t5v0__dffq_1
X_3826_ _3826_/D clkload8/I _3826_/Q VDD VDD VSS VSS gf180mcu_fd_sc_mcu7t5v0__dffq_1
X_3757_ _4200_/I _3854_/Q _3757_/S _4155_/D VDD VDD VSS VSS gf180mcu_fd_sc_mcu7t5v0__mux2_2
X_2708_ _3094_/A1 _2714_/A2 _2720_/C VDD VDD VSS VSS gf180mcu_fd_sc_mcu7t5v0__nor2_1
XFILLER_118_387 VDD VDD VSS VSS gf180mcu_fd_sc_mcu7t5v0__fillcap_32
X_3688_ _3688_/A1 _3678_/Z _3688_/B _3746_/B _4127_/D VDD VDD VSS VSS gf180mcu_fd_sc_mcu7t5v0__oai211_1
X_2639_ _3249_/A1 _3896_/Q _2639_/B1 _2639_/B2 _3895_/Q _3247_/A1 _2648_/A1 VDD VDD
+ VSS VSS gf180mcu_fd_sc_mcu7t5v0__aoi222_1
XFILLER_87_422 VDD VDD VSS VSS gf180mcu_fd_sc_mcu7t5v0__fillcap_4
XFILLER_99_282 VDD VDD VSS VSS gf180mcu_fd_sc_mcu7t5v0__fill_2
XFILLER_30_208 VDD VDD VSS VSS gf180mcu_fd_sc_mcu7t5v0__fillcap_4
XFILLER_11_422 VDD VDD VSS VSS gf180mcu_fd_sc_mcu7t5v0__fillcap_4
XFILLER_23_74 VDD VDD VSS VSS gf180mcu_fd_sc_mcu7t5v0__fill_1
XFILLER_23_96 VDD VDD VSS VSS gf180mcu_fd_sc_mcu7t5v0__fillcap_8
XFILLER_38_308 VDD VDD VSS VSS gf180mcu_fd_sc_mcu7t5v0__fillcap_4
XFILLER_65_105 VDD VDD VSS VSS gf180mcu_fd_sc_mcu7t5v0__fill_1
XFILLER_80_119 VDD VDD VSS VSS gf180mcu_fd_sc_mcu7t5v0__fill_2
XFILLER_9_10 VDD VDD VSS VSS gf180mcu_fd_sc_mcu7t5v0__fillcap_4
X_2990_ _2345_/C _2990_/A2 _3921_/D VDD VDD VSS VSS gf180mcu_fd_sc_mcu7t5v0__nor2_1
X_1941_ _4004_/Q _3219_/A1 VDD VDD VSS VSS gf180mcu_fd_sc_mcu7t5v0__clkinv_1
X_3611_ _4133_/Q _3667_/A2 _3679_/A1 _4125_/Q _3611_/C1 _3667_/C2 _3612_/A2 VDD VDD
+ VSS VSS gf180mcu_fd_sc_mcu7t5v0__aoi222_1
XFILLER_115_302 VDD VDD VSS VSS gf180mcu_fd_sc_mcu7t5v0__fill_2
XFILLER_50_2 VDD VDD VSS VSS gf180mcu_fd_sc_mcu7t5v0__fillcap_4
X_3542_ _4100_/Q _3538_/B _3545_/A3 _4100_/D VDD VDD VSS VSS gf180mcu_fd_sc_mcu7t5v0__and3_1
X_3473_ _3552_/C _3473_/A2 _4082_/D VDD VDD VSS VSS gf180mcu_fd_sc_mcu7t5v0__nor2_1
X_2424_ _3873_/Q _2424_/A2 _2461_/A2 VDD VDD VSS VSS gf180mcu_fd_sc_mcu7t5v0__nor2_1
X_2355_ _2356_/B _2360_/A3 _2358_/A2 VDD VDD VSS VSS gf180mcu_fd_sc_mcu7t5v0__nor2_1
XFILLER_69_422 VDD VDD VSS VSS gf180mcu_fd_sc_mcu7t5v0__fillcap_4
X_2286_ _2279_/Z _2281_/Z _2284_/Z _2285_/Z _2287_/A2 VDD VDD VSS VSS gf180mcu_fd_sc_mcu7t5v0__nor4_1
XFILLER_56_138 VDD VDD VSS VSS gf180mcu_fd_sc_mcu7t5v0__fillcap_4
XTAP_TAPCELL_ROW_67_656 VDD VSS gf180mcu_fd_sc_mcu7t5v0__filltie
X_4025_ _4025_/D _4155_/CLK _4025_/Q VDD VDD VSS VSS gf180mcu_fd_sc_mcu7t5v0__dffq_1
XFILLER_37_385 VDD VDD VSS VSS gf180mcu_fd_sc_mcu7t5v0__fill_2
X_3809_ _3809_/D clkload7/I _3809_/Q VDD VDD VSS VSS gf180mcu_fd_sc_mcu7t5v0__dffq_1
XFILLER_109_22 VDD VDD VSS VSS gf180mcu_fd_sc_mcu7t5v0__fill_1
Xclkbuf_0__1538_ _3549_/ZN clkbuf_0__1538_/Z VDD VDD VSS VSS gf180mcu_fd_sc_mcu7t5v0__clkbuf_16
XFILLER_109_77 VDD VDD VSS VSS gf180mcu_fd_sc_mcu7t5v0__fill_2
XFILLER_121_305 VDD VDD VSS VSS gf180mcu_fd_sc_mcu7t5v0__fill_1
XFILLER_79_208 VDD VDD VSS VSS gf180mcu_fd_sc_mcu7t5v0__fill_2
XFILLER_79_219 VDD VDD VSS VSS gf180mcu_fd_sc_mcu7t5v0__fill_1
XFILLER_87_263 VDD VDD VSS VSS gf180mcu_fd_sc_mcu7t5v0__fill_1
XTAP_TAPCELL_ROW_58_601 VDD VSS gf180mcu_fd_sc_mcu7t5v0__filltie
XTAP_TAPCELL_ROW_41_501 VDD VSS gf180mcu_fd_sc_mcu7t5v0__filltie
XFILLER_11_252 VDD VDD VSS VSS gf180mcu_fd_sc_mcu7t5v0__fill_1
XFILLER_7_212 VDD VDD VSS VSS gf180mcu_fd_sc_mcu7t5v0__fill_1
XFILLER_7_245 VDD VDD VSS VSS gf180mcu_fd_sc_mcu7t5v0__fillcap_4
XFILLER_7_278 VDD VDD VSS VSS gf180mcu_fd_sc_mcu7t5v0__fill_2
XFILLER_59_92 VDD VDD VSS VSS gf180mcu_fd_sc_mcu7t5v0__fill_1
XFILLER_120_382 VDD VDD VSS VSS gf180mcu_fd_sc_mcu7t5v0__fill_2
X_2140_ _4048_/Q _2155_/A2 _2142_/A1 VDD VDD VSS VSS gf180mcu_fd_sc_mcu7t5v0__nor2_1
XFILLER_38_116 VDD VDD VSS VSS gf180mcu_fd_sc_mcu7t5v0__fill_2
X_2071_ _3886_/Q _2706_/A2 VDD VDD VSS VSS gf180mcu_fd_sc_mcu7t5v0__clkinv_1
XFILLER_81_417 VDD VDD VSS VSS gf180mcu_fd_sc_mcu7t5v0__fill_2
Xload_slew84 _2345_/C _3731_/C VDD VDD VSS VSS gf180mcu_fd_sc_mcu7t5v0__buf_4
XTAP_TAPCELL_ROW_64_637 VDD VSS gf180mcu_fd_sc_mcu7t5v0__filltie
X_2973_ _2973_/A1 _2973_/A2 _2973_/A3 _2974_/C VDD VDD VSS VSS gf180mcu_fd_sc_mcu7t5v0__nand3_1
X_1924_ _4021_/Q _3255_/A1 VDD VDD VSS VSS gf180mcu_fd_sc_mcu7t5v0__clkinv_1
X_3525_ _4095_/Q _4094_/Q _4093_/Q _3511_/Z _3525_/Z VDD VDD VSS VSS gf180mcu_fd_sc_mcu7t5v0__and4_1
X_3456_ _3548_/A1 _4104_/Q _3551_/A2 VDD VDD VSS VSS gf180mcu_fd_sc_mcu7t5v0__nor2_1
X_2407_ _2407_/I _3847_/D VDD VDD VSS VSS gf180mcu_fd_sc_mcu7t5v0__clkinv_1
X_3387_ _3387_/A1 _3387_/A2 _3387_/A3 _3386_/Z _3393_/B VDD VDD VSS VSS gf180mcu_fd_sc_mcu7t5v0__nand4_1
X_2338_ _2338_/A1 _2356_/B _2343_/S VDD VDD VSS VSS gf180mcu_fd_sc_mcu7t5v0__nor2_1
X_2269_ _3823_/Q _2269_/A2 _2269_/A3 _2271_/A2 VDD VDD VSS VSS gf180mcu_fd_sc_mcu7t5v0__nand3_1
X_4008_ _4008_/D clkload1/I _4008_/Q VDD VDD VSS VSS gf180mcu_fd_sc_mcu7t5v0__dffq_1
XPHY_EDGE_ROW_9_Left_131 VDD VSS gf180mcu_fd_sc_mcu7t5v0__endcap
XTAP_TAPCELL_ROW_107_896 VDD VSS gf180mcu_fd_sc_mcu7t5v0__filltie
XFILLER_52_174 VDD VDD VSS VSS gf180mcu_fd_sc_mcu7t5v0__fill_1
XFILLER_106_143 VDD VDD VSS VSS gf180mcu_fd_sc_mcu7t5v0__fillcap_4
XFILLER_0_410 VDD VDD VSS VSS gf180mcu_fd_sc_mcu7t5v0__fillcap_16
XFILLER_121_146 VDD VDD VSS VSS gf180mcu_fd_sc_mcu7t5v0__fill_2
XTAP_TAPCELL_ROW_78_718 VDD VSS gf180mcu_fd_sc_mcu7t5v0__filltie
XTAP_TAPCELL_ROW_3_270 VDD VSS gf180mcu_fd_sc_mcu7t5v0__filltie
XFILLER_90_247 VDD VDD VSS VSS gf180mcu_fd_sc_mcu7t5v0__fillcap_4
XFILLER_45_72 VDD VDD VSS VSS gf180mcu_fd_sc_mcu7t5v0__fill_1
XTAP_TAPCELL_ROW_61_618 VDD VSS gf180mcu_fd_sc_mcu7t5v0__filltie
XFILLER_31_347 VDD VDD VSS VSS gf180mcu_fd_sc_mcu7t5v0__fill_2
XFILLER_117_419 VDD VDD VSS VSS gf180mcu_fd_sc_mcu7t5v0__fill_1
XFILLER_6_88 VDD VDD VSS VSS gf180mcu_fd_sc_mcu7t5v0__fill_1
X_3310_ _4044_/Q _4043_/Q _4042_/Q _3302_/Z _3310_/Z VDD VDD VSS VSS gf180mcu_fd_sc_mcu7t5v0__and4_1
X_3241_ _3241_/A1 _3241_/A2 _3243_/A2 VDD VDD VSS VSS gf180mcu_fd_sc_mcu7t5v0__nand2_1
X_3172_ _3172_/A1 _3172_/A2 _3172_/B _3982_/D VDD VDD VSS VSS gf180mcu_fd_sc_mcu7t5v0__aoi21_1
XFILLER_66_244 VDD VDD VSS VSS gf180mcu_fd_sc_mcu7t5v0__fill_1
X_2123_ _3761_/Q _2243_/A2 _3746_/B _2124_/A2 VDD VDD VSS VSS gf180mcu_fd_sc_mcu7t5v0__oai21_1
XFILLER_66_277 VDD VDD VSS VSS gf180mcu_fd_sc_mcu7t5v0__fill_1
X_2054_ _3906_/Q _2845_/A2 VDD VDD VSS VSS gf180mcu_fd_sc_mcu7t5v0__clkinv_1
XFILLER_34_152 VDD VDD VSS VSS gf180mcu_fd_sc_mcu7t5v0__fillcap_4
XFILLER_22_314 VDD VDD VSS VSS gf180mcu_fd_sc_mcu7t5v0__fill_1
XTAP_TAPCELL_ROW_104_877 VDD VSS gf180mcu_fd_sc_mcu7t5v0__filltie
XFILLER_22_347 VDD VDD VSS VSS gf180mcu_fd_sc_mcu7t5v0__fillcap_32
X_2956_ _3022_/A3 _3597_/A2 _3040_/B1 VDD VDD VSS VSS gf180mcu_fd_sc_mcu7t5v0__nor2_1
X_1907_ _4038_/Q _3291_/A1 VDD VDD VSS VSS gf180mcu_fd_sc_mcu7t5v0__clkinv_1
X_2887_ _3147_/A1 _2887_/A2 _2897_/B2 VDD VDD VSS VSS gf180mcu_fd_sc_mcu7t5v0__nand2_1
XTAP_TAPCELL_ROW_9_307 VDD VSS gf180mcu_fd_sc_mcu7t5v0__filltie
XFILLER_1_207 VDD VDD VSS VSS gf180mcu_fd_sc_mcu7t5v0__fill_2
X_3508_ _3508_/I _3509_/B2 VDD VDD VSS VSS gf180mcu_fd_sc_mcu7t5v0__clkinv_1
X_3439_ _4079_/Q _3436_/Z _3439_/B _3440_/B VDD VDD VSS VSS gf180mcu_fd_sc_mcu7t5v0__oai21_1
XTAP_TAPCELL_ROW_0_251 VDD VSS gf180mcu_fd_sc_mcu7t5v0__filltie
XFILLER_72_247 VDD VDD VSS VSS gf180mcu_fd_sc_mcu7t5v0__fillcap_16
XFILLER_15_53 VDD VDD VSS VSS gf180mcu_fd_sc_mcu7t5v0__fill_2
XFILLER_13_347 VDD VDD VSS VSS gf180mcu_fd_sc_mcu7t5v0__fill_2
Xoutput6 output6/I PAD_A[0] VDD VDD VSS VSS gf180mcu_fd_sc_mcu7t5v0__dlyb_1
XFILLER_95_306 VDD VDD VSS VSS gf180mcu_fd_sc_mcu7t5v0__fillcap_4
XFILLER_0_240 VDD VDD VSS VSS gf180mcu_fd_sc_mcu7t5v0__fillcap_32
XTAP_TAPCELL_ROW_118_958 VDD VSS gf180mcu_fd_sc_mcu7t5v0__filltie
XFILLER_63_258 VDD VDD VSS VSS gf180mcu_fd_sc_mcu7t5v0__fill_1
X_2810_ _2810_/I _2819_/A1 VDD VDD VSS VSS gf180mcu_fd_sc_mcu7t5v0__clkinv_1
XFILLER_31_177 VDD VDD VSS VSS gf180mcu_fd_sc_mcu7t5v0__fill_1
X_3790_ _3790_/D clkload4/I _3790_/Q VDD VDD VSS VSS gf180mcu_fd_sc_mcu7t5v0__dffq_1
XTAP_TAPCELL_ROW_101_858 VDD VSS gf180mcu_fd_sc_mcu7t5v0__filltie
X_2741_ _3950_/Q _3892_/Q _2741_/Z VDD VDD VSS VSS gf180mcu_fd_sc_mcu7t5v0__or2_1
X_2672_ _3283_/A1 _3912_/Q _2684_/B VDD VDD VSS VSS gf180mcu_fd_sc_mcu7t5v0__nand2_1
XFILLER_113_422 VDD VDD VSS VSS gf180mcu_fd_sc_mcu7t5v0__fillcap_4
XFILLER_98_133 VDD VDD VSS VSS gf180mcu_fd_sc_mcu7t5v0__fill_1
Xclkbuf_leaf_4__1473_ clkbuf_leaf_4__1473_/I _3527_/B VDD VDD VSS VSS gf180mcu_fd_sc_mcu7t5v0__clkbuf_8
X_3224_ _3224_/A1 _3241_/A2 _3240_/A2 VDD VDD VSS VSS gf180mcu_fd_sc_mcu7t5v0__nand2_1
XTAP_TAPCELL_ROW_97_835 VDD VSS gf180mcu_fd_sc_mcu7t5v0__filltie
XFILLER_98_177 VDD VDD VSS VSS gf180mcu_fd_sc_mcu7t5v0__fillcap_8
.ends
