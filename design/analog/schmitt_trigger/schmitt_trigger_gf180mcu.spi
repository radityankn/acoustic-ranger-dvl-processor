* =====================================================================
* SCHMITT TRIGGER  --  Analog signal-conditioning block, DVL receiver AFE
* Team Acoustic Ranger | Ultrasonic Array Receiver for Doppler Velocity Logger
* Target PDK : GF180MCU (3.3 V LV devices, nfet_03v3 / pfet_03v3)
* Simulator  : ngspice (hand-built schematic, no auto-routing)
* File format: SPICE netlist (.spi)
* =====================================================================
*
* FUNCTION IN SIGNAL CHAIN
*   [Amplifier] -> [Narrowband filter ~1 MHz] -> [THIS BLOCK] -> [TDC]
*   Converts the filtered sinusoid into a clean rail-to-rail square wave
*   whose edges carry the round-trip timing and Doppler-shifted frequency.
*   Hysteresis gives built-in noise squelch: between echo pings, noise
*   riding on the mid-rail bias stays inside the window and the output
*   holds its last state (no false edges into the TDC).
*
* TOPOLOGY: classic 6-transistor CMOS Schmitt trigger (inverting core)
*           + output inverter buffer  =>  overall NON-INVERTING.
*   Chosen over a comparator+resistive-feedback solution because it is
*   all-MOS (no passives -> tiny area, no resistor layout constraints),
*   has no DC bias network, and is the simplest hand-built option,
*   matching the "narrowband / design simplicity" decision in the
*   2026-06-11 meeting minutes.
*
* CONNECTIVITY (D = drain, G = gate, S = source, B = bulk)
*   NMOS stack :  GND -S- M1 -D- n1 -S- M2 -D- outc      (G1=G2=in)
*   NMOS fdbk  :  M3: D=VDD, G=outc, S=n1, B=GND    pulls n1 high
*                 while outc is high -> raises the rising trip point
*   PMOS stack :  VDD -S- M4 -D- n2 -S- M5 -D- outc      (G4=G5=in)
*   PMOS fdbk  :  M6: D=GND, G=outc, S=n2, B=VDD    pulls n2 low
*                 while outc is low  -> lowers the falling trip point
*   Buffer     :  M7/M8 inverter, outc -> out (sharpens edges, isolates
*                 the regenerative node from the TDC load, restores
*                 non-inverting polarity)
*
* DESIGN EQUATIONS (square-law, body effect neglected; final values
* must be tuned in simulation -- see testbench tb_schmitt_hysteresis):
*   Rising threshold  : B1/B3 = [ (VDD - VSPH) / (VSPH - VTN ) ]^2
*   Falling threshold : B4/B6 = [ VSPL / (VDD - VSPL - |VTP|) ]^2
*   where Bx = (W/L)x within the same device type (mobility cancels).
*   GF180MCU 3.3 V typicals: VTN ~ +0.63 V, VTP ~ -0.73 V.
*   With B1=B3 and B4=B6 the ideal window is ~1.29 V / 1.97 V; the
*   ratios below were trimmed in simulation to compensate body effect.
*
* SIZING RATIONALE
*   - L = 2 um in the core: speed is irrelevant at 1 MHz, so long L is
*     used to cut the static current that flows through one stack while
*     the input idles inside the window between pings (verified ~35 uA;
*     L=0.5 um version drew ~10x more). Also improves matching.
*   - Feedback/driver W ratios (0.7/1.0 NMOS, 1.3/2.0 PMOS) center the
*     window at ~VDD/2 with ~0.7 V hysteresis (verified 1.28 / 1.98 V).
*   - PMOS ~2x NMOS width: compensates Idsat ratio (~510 vs ~250 uA/um).
*   - Buffer uses short L (0.5 um) for sub-ns edges into the TDC.
*
* VERIFIED PERFORMANCE (ngspice, surrogate models fitted to GF180MCU
* 3.3 V typicals; re-verify on PDK corners before schematic freeze):
*   VSPH = 1.98 V | VSPL = 1.28 V | hysteresis = 0.70 V | center 1.63 V
*   tpd ~ 5.5 ns | tr/tf ~ 0.5 ns @ 100 fF | duty 50.6 % @ 1 MHz
*   P_idle ~ 114 uW (input parked at 1.65 V) | P_toggle ~ 33 uW @ 1 MHz
*   Squelch: 0.25 Vpk @ 1 MHz around bias -> zero output transitions
*
* TUNING KNOBS (re-run tb_schmitt_hysteresis after any change)
*   - Raise VSPH  : decrease W1,W2 or increase W3
*   - Raise VSPL  : decrease W4,W5 or increase W6
*   - Less static current: increase L (all core devices equally)
*   - Smaller hysteresis (if amplifier swing is limited): move both
*     ratios toward each other; keep >= 6x expected input noise pk-pk.
* =====================================================================

.subckt schmitt_trigger_dvl in out vdd vss

* ---------------- regenerative core (inverting) ----------------
* name   D     G     S    B    model       W       L
XM1      n1    in    vss  vss  nfet_03v3   W=1.0u  L=2u  nf=1
XM2      outc  in    n1   vss  nfet_03v3   W=1.0u  L=2u  nf=1
XM3      vdd   outc  n1   vss  nfet_03v3   W=0.7u  L=2u  nf=1
XM4      n2    in    vdd  vdd  pfet_03v3   W=2.0u  L=2u  nf=1
XM5      outc  in    n2   vdd  pfet_03v3   W=2.0u  L=2u  nf=1
XM6      vss   outc  n2   vdd  pfet_03v3   W=1.3u  L=2u  nf=1

* ---------------- output buffer (restores polarity) -------------
XM7      out   outc  vdd  vdd  pfet_03v3   W=4.0u  L=0.5u nf=1
XM8      out   outc  vss  vss  nfet_03v3   W=2.0u  L=0.5u nf=1

.ends schmitt_trigger_dvl

* NOTES FOR LAYOUT (no passive components in this block):
*   - Estimated active area well under 500 um^2 incl. guard rings.
*   - Place M1/M3 and M4/M6 pairs close together with same orientation
*     (their ratio sets the thresholds); deep n-well not required.
*   - Surround the core with a guard ring: outc is a fast regenerative
*     node next to sensitive analog (filter) circuitry.
*   - After extraction, re-run both testbenches with parasitics.
